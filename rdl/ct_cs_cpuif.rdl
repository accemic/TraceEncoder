// SPDX-FileCopyrightText: 2026 Accemic Technologies GmbH
// SPDX-License-Identifier: CERN-OHL-S-2.0 OR LicenseRef-Accemic-Commercial

// ----------------------------------------------------
// CEDARtools.TraceEncoder (CTTE) address map
// ----------------------------------------------------

// Build-profile defines (generated by scripts/gen_rdl_profile.py from the
// CT_EN_* switches in rtl/pkg/ct_pkg.sv; the committed default is the FULL
// profile = no defines = historical register map). A CT_PROFILE_NO_<X>
// define turns the feature group's config fields into sw=r constants:
// their storage and write decode vanish, the hwif output keeps its member
// (constant reset value), and reads return the reset value ("compiled-out
// feature's CSR bits read as 0").
`include "ct_profile.inc.rdl"

addrmap ct_cs_cpuif #(
    longint NUM_TRACE_FILTER              = 16,
    longint NUM_TRACE_COMPARATORS         =  8,
    longint NUM_PERFCNT_IFETCH_TH_RANGES  =  3,
    longint NUM_PERFCNT_DATA_RD_TH_RANGES =  3,
    longint NUM_PERFCNT_DATA_RD_RANGES    =  7,
    longint NUM_PERFCNT_DATA_WR_RANGES    =  7,
    longint NUM_ACT_ST                    = 1023,
    longint NUM_DF_RANGE                  = 15,
    longint MAX_I_FILTER                  =  8,
    longint MAX_J_FILTER                  =  8,
    longint CSC_COUNTER_DATA_RANGE_COUNT  =  2
) {
    name = "CEDARtools.TraceEncoder Control / Status Registers";
    desc = "CEDARtools.TraceEncoder (CTTE) control / status registers.
            The register map follows the RISC-V N-Trace Control Interface specification.
            Registers, fields, and enum values whose description ends in a [CTTE ...] marker -- [CTTE specific], or a qualified form such as [CTTE container] -- are CEDARtools.TraceEncoder extensions; everything else is N-Trace compliant.

            Sub-components:
              0x0000-0x0FFF  te   - Trace Encoder               (N-Trace, CompType=0x1)
              0x1000-0x1FFF  atb  - Trace ATB Bridge             (N-Trace, CompType=0xE)
              0x3000-0x3FFF  pc   - Performance Counters         [CTTE, CompType=0x3 vendor]
              0x4000-0x4FFF  wp   - Watchpoints (ACT-ST)         [CTTE, CompType=0x4 vendor]
              0x5000-0x7FFF  df   - DF Range Filter              [CTTE, CompType=0x5 vendor]

            Each component has a trXxControl (Active bit) + trXxImpl (version/CompType) pair at
            offsets 0x000 / 0x004 of its base, per N-Trace spec Section 4.3. [CTTE container]";
    default regwidth = 32;
    default sw = r;
    default hw = r;

    // --------------------------------------------------
    // ACT-CAP / ACT-ST command encoding
    // --------------------------------------------------
    // Note on DirectData encoding: DirectData is always transmitted as part of the DAQ message.
    // A value of 0 incurs zero overhead because the Nexus MDO/MSEO variable-length field
    // encoding strips leading zeros — an all-zero field occupies no additional MDO cycles.
    // There is therefore no "non-negative" guard: callers that do not need extra data simply
    // leave DirectData=0.
    enum trActCapStCmd_e {
        ACT_CAP_ST_NONE              =  0 { desc = "Do nothing."; };
        ACT_CAP_ST_DAQ_PC_CURR       =  1 { desc = "Transmit DAQ message containing the current program counter (PC) plus direct data[23:0]."; };
        ACT_CAP_ST_DAQ_PC_CURR_LAST  =  2 { desc = "Transmit DAQ message with current PC, previous PC before exception or interrupt, plus direct data[23:0]."; };
        ACT_CAP_ST_DAQ_DIRECT_DATA   =  3 { desc = "Transmit DAQ message with direct data value."; };
        ACT_CAP_ST_DAQ_DATA          =  4 { desc = "Transmit DAQ message with data value and context (data size, data type) of the next data access, plus direct data[23:0]."; };
        ACT_CAP_ST_DAQ_DADDR         =  5 { desc = "Transmit DAQ message with data address and context (data size, data type) for the next data access, plus direct data[23:0]."; };
        ACT_CAP_ST_DAQ_DATA_DADDR    =  6 { desc = "Transmit DAQ message with data value, data address, and context (data size, data type) for the next data access, plus direct data[23:0]."; };
//      ACT_CAP_ST_DAQ_STALL_COUNTER =  7 { desc = "Transmit DAQ message with stall counter value plus direct data[23:0], then reset the stall counter."; };
        ACT_CAP_ST_DAQ_IFETCH_TH     =  8 { desc = "Transmit DAQ message with count of instruction fetches exceeding cycle threshold per region (direct_data[7:0]), plus direct data[23:8], then reset the counter."; };
        ACT_CAP_ST_DAQ_DATA_RD_TH    =  9 { desc = "Transmit DAQ message with count of read accesses exceeding cycle threshold per region (direct_data[7:0]), plus direct data[23:8], then reset the counter."; };
        ACT_CAP_ST_DAQ_DATA_WR       = 10 { desc = "Transmit DAQ message with count of write accesses for region (direct_data[7:0]), plus direct data[23:8], then reset the counter."; };
        ACT_CAP_ST_DAQ_DATA_RD       = 11 { desc = "Transmit DAQ message with count of read accesses for region (direct_data[7:0]), plus direct data[23:8], then reset the counter."; };
        ACT_CAP_ST_CF_SYNC           = 12 { desc = "Transmit instruction synchronization message (Nexus message only)."; };
        ACT_CAP_ST_WATCHPOINT        = 14 { desc = "Transmit Watchpoint message (Nexus TCODE 15) reporting WHICH watchpoint fired.
                                                   WPHIT = direct_data[15:0] AND trWpMask.WEM, so software owns the slot<->bit
                                                   convention (give each watchpoints[] slot the bit you want to see) and the
                                                   WEM mask decides which slots may report at all. A command whose masked
                                                   result is 0 emits nothing. Requires the CT_EN_WATCHPOINT_MSG build switch;
                                                   unlike the DAQ commands this one produces no Data Acquisition message. [CTTE specific]"; };
        ACT_CAP_ST_TE                = 13 { desc = "Set TE field (direct_data[7:0]), value: direct_data[23:8].
//                                                  TE field 0: trTeControl.InstTracing (set/clear instruction tracing)
//                                                  TE field 1: trTeControl.DataTracing (set/clear data tracing)
//                                                  TE field 2: trTeControl.InstSyncReq -- [NOT IMPLEMENTED] as an
//                                                  ACT-CAP set-TE-field command, and not needed: a hart that wants a
//                                                  synchronization message uses the ACT_CAP_ST_CF_SYNC command, while
//                                                  the control bus writes trTeControl.InstSyncReq directly (both end
//                                                  up as SYNC = 14).                                             "; };
    };

    enum trActCapStSink_e {
        ACT_CAP_ST_SINK_NEXUS      = 0 { desc = "Nexus message"; };
        ACT_CAP_ST_SINK_AXIS       = 1 { desc = "AXIS to internal CPU"; };
        ACT_CAP_ST_SINK_AXIS_NEXUS = 2 { desc = "AXIS to internal CPU, and Nexus message"; };
        ACT_CAP_ST_SINK_TE         = 3 { desc = "set TE register only)"; };
    };

    // --------------------------------------------------------------------
    // Canonical ACT-CAP command word type anchor.
    //
    // Declares the {Cmd, Sink, DirectData} bit layout shared by:
    //   - the watchpoints memory Cmd word (ct_cs_cpuif.watchpoints[].Cmd),
    //   - RISC-V CSR 0x0B10 (ACT-CAP protocol, CPU-side only — see
    //     tip_pkg::cmd_to_tip_data), and
    //   - the RTL act_cap/act_st data path.
    //
    // Marked `ispresent = false` so the register is hidden from every
    // exporter (HTML, C, regblock): the hardware does NOT decode 0x0B10 on
    // the MMIO bus and showing it would mislead developers.
    //
    // The declaration is still needed as a type anchor.
    // `generate_wb_pkg` walks the compiled RDL (where the node IS
    // reachable regardless of ispresent) and emits matching SystemVerilog
    // enum + struct typedefs into ct_cs_cpuif_types_pkg.sv for use by the
    // RTL.
    // --------------------------------------------------------------------
    reg {
        name = "ACT-CAP Command (type anchor, hidden)";
        desc = "Type anchor only. Hidden via ispresent=false. [CTTE specific]";

        field { desc = "HSI command";            encode = trActCapStCmd_e;  sw=rw; } Cmd[5:0]         = 0;
        field { desc = "Sink";                   encode = trActCapStSink_e; sw=rw; } Sink[7:6]        = 0;
        field { desc = "Direct data (24 bits)."; sw=rw;                            } DirectData[31:8] = 0;
    } trActCapStCmd @ 0x0B10;
    trActCapStCmd->ispresent = false;

    // ====================================================================
    // ct_te - Trace Encoder sub-component @ 0x0000 (N-Trace compliant, 4 KB)
    // Matches the spec's trTe??/trTs?? register layout (RISC-V Trace Control
    // Interface Spec, Table 4). Paths are hwif_*.te.trTeXxx.
    // ====================================================================
    regfile {
        name = "Trace Encoder";
        desc = "Trace Encoder sub-component (N-Trace compliant, CompType=0x1).
                See RISC-V N-Trace Control Interface spec Table 4.";
        default regwidth = 32;
        default sw = r;
        default hw = r;

    // ====================================================================
    // trTeControl - Trace Encoder Control Register @ 0x000
    // ====================================================================
    reg {
        name = "CTTE Encoder Control Register";
        desc = "Primary control register for the CTTE Encoder";

        field {
            desc = "Primary enable/reset for the Trace Encoder";
            sw = rw;
        } Active[0:0] = 0;

        field {
            desc = "1: Trace Encoder is enabled. Allows trTeInstTracing and
                    trTeDataTracing to turn tracing on and off. Setting trTeEnable to 0
                    flushes any queued trace data to the sink or funnel attached to this
                    encoder. This bit can be set to 1 only by direct writing to it. This write
                    of 1 should be done after all other settings are done.
                    Enable gates instruction and data tracing: effective instruction
                    tracing is (Enable AND trTeInstTracing). Clearing Enable therefore
                    implicitly disables instruction (and data) tracing without rewriting
                    those bits; the resulting instruction-tracing-disabled edge generates
                    the trace-off Program Trace Correlation Message (see trTeInstTracing).
                    [CTTE: the implicit-disable gating is RTL, not an RDL auto-clear.]";
            sw = rw;
        } Enable[1:1] = 0;

        field {
            desc = "Instruction trace generation. Effective instruction tracing is
                    (trTeControl.Enable AND this bit). The 1->0 edge of effective
                    instruction tracing (this bit cleared, or Enable cleared) makes the
                    encoder emit a Program Trace Correlation Message (TCODE 33,
                    EVCODE=Program Trace Disabled) carrying the residual instruction
                    count and branch history, so a decoder can resolve the final
                    instructions up to the trace-off point; the 0->1 edge emits a
                    TRACE_ENABLE synchronization message to re-anchor the decoder.
                    [CTTE specific]";
            sw = rw; hwclr; hwset;
        } InstTracing[2:2] = 0;

        field {
            desc = "Reads as 1 when all generated trace has been emitted";
            hw = w;
        } Empty[3:3] = 1;

        enum trTeInstMode_e {
         // ITR_FULL             = 0 { desc = "Full Instruction trace is disabled, but trace may still emit some records"; };
         // ITR_BRANCH_RES0      = 1 { desc = "Reserved for subsets of Branch Trace (e.g. periodic PC sampling)"; };
         // ITR_BRANCH_RES1      = 2 { desc = "Reserved for subsets of Branch Trace (e.g. periodic PC sampling)"; };
            ITR_BRANCH           = 3 { desc = "Generate instruction trace using Branch Trace Messaging (BTM: Nexus DirectBranch TCODE 3 / IndirectBranch TCODE 4 -- one message per taken/indirect branch). Legal iff the CT_EN_BTM build switch is set; otherwise WARL-legalized to 6."; };
         // ITR_BRANCH_HIST_RES0 = 4 { desc = "Reserved for subset of Branch History Trace"; };
         // ITR_BRANCH_HIST_RES1 = 5 { desc = "Reserved for subset of Branch History Trace"; };
            ITR_BRANCH_HIST      = 6 { desc = "Generate instruction trace using Branch History Trace (HTM)"; };
         // ITR_VENDOR           = 7 { desc = "User External Interrupt"; };
        };
        field {
            desc = "Instruction trace generation mode. Only accessible on trTeControl. Enable=0.
                    WARL: legal values are 6 (ITR_BRANCH_HIST, HTM) always, and 3
                    (ITR_BRANCH, BTM) iff the CT_EN_BTM build switch is set. With both
                    modes settable, N-Trace Table 8 ('3 OR 6 settable') is fully met.
                    A write of any illegal value is legalized to 6 before it reaches the
                    register; when CT_EN_BTM=0 a write of 3 is likewise legalized to 6
                    (honest 'BTM unsupported' read-back). Legalization lives in
                    ct_cs_cpuif_wb.sv (the Wishbone adapter), not in this generated
                    block. [CTTE specific]";
            encode = trTeInstMode_e;
            sw = rw;
        } InstMode[6:4] = 6;

        enum trTeSendConfigMode_e {
            CFG_NONE    = 0 { desc = "Do send no config message"; };
            CFG_ONCE    = 1 { desc = "Do send config message at trace start (rising edge of effective instruction tracing). Config changes require Enable=0 (swwel), so every relevant change implies a new trace start = a new config message"; };
            CFG_ON_SYNC = 2 { desc = "Like CFG_ONCE, plus one config message after every periodic sync"; };
        };
        field {
            desc = "Send NEXUS_MSG_VENDOR_CONFIG (TCODE 58) messages: the encoder
                    describes its compiled-in capabilities and runtime configuration
                    on-wire so a decoder can configure itself from the stream
                    (self-describing trace; payload layout in rtl/pkg/ct_pkg.sv).
                    Resets to CFG_ONCE in the full profile (AW E6, seq 24);
                    profiles without the feature read CFG_NONE. [CTTE specific]";
            encode = trTeSendConfigMode_e;
            sw = rw;
        } SendConfig[8:7] = 1;

        field {
            desc = "Send Ownership messages (TCODE 2) to indicate processor context:
                    emitted on a context-report ingress event (ctype != 0), on a
                    privilege-level change between retires, and after every
                    synchronizing message (N-Trace 7.1). PROCESS payload =
                    {CONTEXT, V, PRV, FORMAT} per Table 13. [CTTE granularity;
                    TCODE 2 itself is N-Trace standard]";
            sw = rw;
        } Context[9:9] = 0;

        field {
            desc = "Emit a full synchronization message with SYNC=4 (Sequential
                    Instruction Counter) when the internal instruction-count
                    accumulator reaches its cap, instead of the bandwidth-lean
                    ResourceFull(RCODE=0) drain. CAUTION: N-Trace 1.0 allows SYNC=4
                    only in BTM mode; enabling it in the HTM-only CTTE is a
                    documented Accemic extension (any decoder still treats it as a
                    full re-anchor). Reset 0 = RCODE-0 drains (strictly N-Trace).
                    Applies to the composer-side pre-drain (the dominant path for
                    long linear runs); msg_gen-internal drains stay RCODE-0. [CTTE specific]";
            sw = rw;
        } InstSeqSyncEnable[10:10] = 0;

        field {
            desc = "Enable instruction trace trigger: while set, a pulse on the
                    generic tip.trigger event input upgrades the next retire to a
                    synchronization message with SYNC=6 (Trace Event / watchpoint
                    marker, N-Trace Table 25). Integrators wire tip.trigger to a
                    core watchpoint unit or external trigger fabric; the MBV
                    adapter ties it 0 (integration requirement, see
                    doc/supported_configurations.md).";
            sw = rw;
        } InstTrigEnable[11:11] = 0;

        field {
            desc = "Sticky status: set when the encoder generated an OVERFLOW message,
                    i.e. when the eTIP drop path discarded messages and injected the
                    Error(QueueOverrun) marker (N-Trace Required status bit).
                    Write 1 to clear (RW1C); additionally cleared by hardware while
                    trTeControl.Enable = 0, so every trace session starts from a
                    known-clear bit. Pure status -- setting or clearing it has NO
                    effect on the wire stream.
                    STALL HALF NOT IMPLEMENTED: the second half of the standard
                    semantics ('or TE requests hart stall') needs a back channel to
                    the hart. The CTTE ingress port (rtl/pkg/tip_if.sv) is
                    UNIDIRECTIONAL -- there is no stall/ready signal towards the
                    core -- so no CTTE adapter can stall a hart and the companion
                    control bit trTeControl.InstStallEna [13] stays unimplemented
                    (see the commented stub below). The bit therefore reports
                    overflow only. [N-Trace Required, overflow half]";
            sw = rw; onwrite = woclr; hwset; hwclr;
        } InstStallOrOverflow[12:12] = 0;
//      NOT IMPLEMENTED (P7, evidence-based): hart stalling needs a back channel
//      to the core. tip_if.sv is unidirectional (the encoder never drives the
//      ingress port), so this bit could only ever read back as a lie.
//      field { desc = "Enable hart stall if TE cannot send a message"; }                     InstStallEna[13:13]        = 0;

        field {
            desc = "Add source field to trace message.
                    Only accessible on trTeControl. Enable=0";
            sw = rw;
        } InhibitSrc[15:15] = 1;

        enum trTeInstSyncMode_e {
            ITR_SYNC_OFF          = 0 { desc = "No periodic instruction trace synchronization message/packet generation"; };
            ITR_SYNC_TRACE_MSG    = 1 { desc = "Count emitted trace messages: on-wire message boundaries as they
                                               leave the encoder egress (ATB flush pseudo-messages do not count).
                                               A synchronization message is requested once 2^(InstSyncMax+4)
                                               messages were emitted since the last sync. With CT_EN_QUOTA_SYNC=0
                                               the mode stays writable but has no effect (no sync is generated)."; };
            ITR_SYNC_CLK_CYCLES   = 2 { desc = "Count hart clock cycles"; };
            ITR_SYNC_HALFWORDS    = 3 { desc = "Count instruction half-words (16-bit)"; };
            ITR_SYNC_TRACE_BYTES  = 4 { desc = "Count emitted trace bytes as accepted on the ATB output: whole
                                               output beats, so alignment padding and flush idle beats count
                                               toward the quota. A synchronization message is requested once
                                               2^(InstSyncMax+4) bytes were emitted since the last sync -- the
                                               bound a live/ring-buffer consumer programs to make the maximum
                                               re-anchor distance a fixed number of bytes. With
                                               CT_EN_QUOTA_SYNC=0 the mode stays writable but has no effect."; };
            ITR_SYNC_WALL_CLK     = 5 { desc = "Count wallclock cycles"; };
            ITR_SYNC_INSTRUCTIONS = 6 { desc = "Count instructions"; };
            ITR_SYNC_ATB          = 7 { desc = "ATB synq requests [CTTE specific]"; };
        };
        field {
            desc = "Periodic instruction trace synchronization mode.
                    This field combines bits 17 and 16 (standard trTeInstSyncMode) with the two reserved bits 19 and 18.
                    Only accessible on trTeControl. Enable=0";
            encode = trTeInstSyncMode_e;
            sw = rw;
        } InstSyncMode[19:16] = 0;

        field {
            desc = "Maximum interval between sync messages (2^(trTeInstSyncMax+4)).
                    The unit follows InstSyncMode: on-wire trace messages (mode 1),
                    hart clock cycles (2), instruction half-words (3), emitted ATB
                    trace bytes (4), wallclock cycles (5) or instructions (6).

                    Resets to 6, i.e. a period of 2^(6+4) = 1024 units in
                    whichever unit InstSyncMode selects. The reset value matters
                    because the natural programming path is ONE write to
                    trTeControl ('periodic sync, counted in X'), which takes the
                    mode from software and the period from here. 1024 is the knee
                    of the measured cost curve: the periodic sync then costs 2.5 %
                    of the trace stream, while every wider period can save at most
                    those 2.5 % and doubles the blind window of a consumer that
                    attaches mid-stream. The minimum period (0 = every 16 units)
                    costs a factor 2.4 on the same workload and loses trace against
                    a finite sink -- it remains available as an explicit stress
                    configuration, but it is not a product default (P0-02;
                    gate tests/instruction/37_sync_cadence -- the raw
                    measurement behind those numbers is not part of this
                    repository).
                    Only accessible on trTeControl. Enable=0";
            sw = rw;
        } InstSyncMax[23:20] = 6;

        enum trTeFormat_e {
         // TR_FORMAT_E      = 0 { desc = "Format defined by Efficient Trace for RISC-V (E-Trace) Specification"; };
            TR_FORMAT_N      = 1 { desc = "N-Trace messages with 6 MDO + 2 MSEO bits"; };
         // TR_FORMAT_RES0   = 2 { desc = "Reserved for future formats"; };
         // TR_FORMAT_RES1   = 3 { desc = "Reserved for future formats"; };
         // TR_FORMAT_RES2   = 4 { desc = "Reserved for future formats"; };
         // TR_FORMAT_RES3   = 5 { desc = "Reserved for future formats"; };
         // TR_FORMAT_RES4   = 6 { desc = "Reserved for future formats"; };
         // TR_FORMAT_VENDOR = 7 { desc = "Vendor-specific format"; };
        };
        field {
            desc = "Trace recording format.
                    Only accessible on trTeControl. Enable=0";
            encode = trTeFormat_e;
        } Format[26:24] = 1;

        field {
            desc = "Explicit instruction-trace synchronization request (TCI trTeInstSyncReq).
                    Write-1 semantics: the write raises ONE request and the field clears
                    itself in the next cycle, so it always reads back 0. The request is
                    served by the sync generator on the first qualifying retired
                    instruction and appears on the wire as the explicit-request code
                    SYNC = 14 -- the same code the ACT-CAP CF_SYNC command and the ATB
                    sync-request input produce, because the source is irrelevant to a
                    decoder (every synchronization message is a full re-anchor). For
                    diagnosis the source is recorded in trTeSyncStatus.SyncReqSource
                    (value 4, SYNC_REQ_TE).
                    Deliberately NOT gated on trTeInstSyncMode: unlike the ATB request
                    (mode 7) this field is itself the trigger and works in every cadence
                    mode. A request written while instruction tracing is paused is
                    DEFERRED, not dropped: it is served after the resume anchor.
                    Request depth is one in flight plus one remembered: a write arriving
                    while a request is still outstanding is NOT swallowed -- it is
                    launched as its own request as soon as the outstanding one has been
                    served and produces its OWN synchronization message. Only a write
                    that arrives when a request is already waiting to be launched
                    collapses into it (it asks for what is about to be asked anyway).
                    Measured on the system test (scripts/cli_tesyncreq_test.sh, legs
                    req/req2/req3): one write -> 1 SYNC = 14, two writes back to back ->
                    2, three writes back to back -> 2.
                    Requires the CT_EN_INST_SYNC_REQ build switch; without it the write
                    is still accepted and still auto-clears, but nothing consumes it
                    (the pre-2026-08 behaviour). [CTTE specific]";
            sw = w; singlepulse;
        } InstSyncReq[27:27] = 0;

        enum trTeSendDeviceIdMode_e {
            DID_NONE = 0 { desc = "Do not send a Device ID message"; };
            DID_ONCE = 1 { desc = "Send one Device ID message per trace-on edge (rising edge of effective instruction tracing), before the config message and before the first synchronizing message. NOT once per session: after an instruction-tracing pause the message is sent again -- same trigger as SendConfig=CFG_ONCE, and what a decoder attaching during the pause needs"; };
        };
        field {
            desc = "Send a Device ID message (Nexus TCODE 1, IEEE-ISTO 5001 4.3.2)
                    carrying the encoder instance's static identifier (elaboration
                    parameter CT_DEVICE_ID of ct_encoder; layout per ISTO Table B-5
                    RN | PN | MID), so a stock Nexus decoder learns which device
                    produced the stream without out-of-band setup.
                    Resets to DID_NONE -- deliberately UNLIKE SendConfig: N-Trace 1.0
                    does not adopt TCODE 1 (Table 9), so the default stream stays
                    strictly N-Trace 1.0 and byte-identical to the pre-P4 reference.
                    Requires the CT_EN_DEVICE_ID build switch; profiles without the
                    feature read DID_NONE.
                    Bit position: the CTTE-vendor area above InstSyncReq -- bits
                    [13:12] are reserved for the standard TE status/stall fields
                    (trTeInstStallOrOverflow / trTeInstStallEna, see the commented
                    stubs above). [CTTE specific]";
            encode = trTeSendDeviceIdMode_e;
            sw = rw;
        } SendDeviceId[29:28] = 0;
    } trTeControl @ 0x000;

    // ====================================================================
    // trTeImpl - CTTE Encoder Implementation Register @ 0x004
    // ====================================================================
    reg {
        name = "CTTE Encoder Implementation Register";
        desc = "Contains version and protocol information for the CTTE Encoder";

        field { desc = "Trace Encoder Component Major Version"; } VerMajor[3:0]        = 1;
        field { desc = "Trace Encoder Component Minor Version"; } VerMinor[7:4]        = 0;
        field { desc = "Trace Encoder Component Type";          } CompType[11:8]       = 1;
        // Hardware-driven discovery (P9): the back end is a synthesis
        // parameter of THIS encoder instance (ct_encoder EN_NTRACE /
        // EN_ETRACE), so the value comes from the netlist rather than from a
        // profile-wide RDL constant -- in a mixed SoC each encoder must
        // report its own protocol. 1 = N-Trace 1.x, 2 = E-Trace 2.x.
        field {
            desc = "Trace Protocol Major Version (1 = N-Trace, 2 = E-Trace; driven by the compiled-in back end)";
            sw = r; hw = w;
        } ProtocolMajor[19:16] = 1;
        field { desc = "Trace Protocol Minor Version";          } ProtocolMinor[23:20] = 0;
    } trTeImpl @ 0x004;

    // ====================================================================
    // trTeInstFeatures - CTTE Instruction Features Register @ 0x008
    // ====================================================================
    reg {
        name = "CTTE Instruction Features Register";
        desc = "Defines the trace instruction features configuration for the CTTE Encoder.
                Only accessible on trTeControl. Enable=0";

//      field { desc = "Do not send differential addresses when set"; }                                                  InstNoAddrDiff[0:0]         = 0;
//      field { desc = "Do not send trap handler address in trap packets"; }                                             InstNoTrapAddr[1:1]         = 0;
//      field { desc = "Treat sequentially inferrable jumps as inferable PC discontinuities"; }                          InstEnSequentialJump[2:2]   = 0;
        field { desc = "Treat returns as inferable PC discontinuities when returning from a recent call on a stack. Writable only while trTeControl.Enable=0."; sw = rw; } InstEnImplicitReturn[3:3] = 0;
        field { desc = "Enable branch prediction (vendor TCODE 56: mispredict count instead of HIST bits; excludes InstEnRepeatedHistory/InstEnRepeatBranch). Writable only while trTeControl.Enable=0."; sw = rw; } InstEnBranchPrediction[4:4] = 0;
        field { desc = "Enable jump target cache (vendor TCODE 57: target as cache index instead of UADDR). Writable only while trTeControl.Enable=0."; sw = rw; }  InstEnJumpTargetCache[5:5]  = 0;
//
//      enum trTeInstImplicitReturnMode_e {
//          ITR_IMPL_RETURN_OFF     = 0 { desc = "Implicit Return mode is not supported"; };
//          ITR_IMPL_RETURN_SIMPLE  = 1 { desc = "Simple level counting without the return address compare"; };
//          ITR_IMPL_RETURN_PARTIAL = 2 { desc = "Partial compare (LSB portion of return address)"; };
//          ITR_IMPL_RETURN_FULL    = 3 { desc = "Full compare"; };
//      };
//      field {
//          desc = "Implicit Return Mode";
//          encode = trTeInstImplicitReturnMode_e;
//      } InstImplicitReturnMode[7:6] = 0;
//
        field { desc = "Enable repeated branch history. Writable only while trTeControl.Enable=0."; sw = rw; }            InstEnRepeatedHistory[8:8] = 0;
        field { desc = "Enable RepeatBranch messages (TCODE 30) for identical repeated IndirectBranchHistory messages. Writable only while trTeControl.Enable=0."; sw = rw; } InstEnRepeatBranch[11:11] = 0;
        field { desc = "Widen the internal ICNT cap from 8 to 16 bit (fewer ResourceFull ICNT drains; wire ICNT stays variable-length per Nexus). Writable only while trTeControl.Enable=0."; sw = rw; } InstEnWideIcnt[12:12] = 0;
        field { desc = "Emit IndirectBranchHistorySync messages (TCODE 29): synchronizing
                        messages carry the pending branch history instead of pre-flushing
                        it as a separate ResourceFull(RCODE=1) -- one message where two
                        went before (bandwidth win). 0 = historical two-message form.
                        Writable only while trTeControl.Enable=0.
                        [CTTE granularity; TCODE 29 itself is N-Trace standard]"; sw = rw; } InstEnIbhs[13:13] = 0;
        field { desc = "Emit RepeatInstruction messages (TCODE 31/32) for single-instruction
                        spin loops (a taken branch targeting its own address): iterations
                        after the first are counted and the run closes as ONE message with
                        R-CNT instead of one HIST bit per iteration. CAUTION: TCODE 31/32
                        are IEEE-ISTO-5001-2012 (4.3.14/15); N-Trace 1.0 keeps them
                        reserved -- enabling this makes the stream an Accemic/ISTO
                        extension. Reset 0 keeps the stream strictly N-Trace 1.0.
                        Writable only while trTeControl.Enable=0. [CTTE specific]"; sw = rw; } InstEnRepeatInstr[14:14] = 0;
//      field { desc = "Emit trace for direct unconditional/inferable control flow changes (jumps or calls)"; }           InstEnAllJumps[9:9]        = 0;
//      field { desc = "Enable extension of virtual address MSB bits"; }                                                 InstExtendAddrMSB[10:10]   = 0;

        field { desc = "TE source ID

Writable only while trTeControl.Enable=0.";                             sw = rw; } SrcID[27:16]   = 10;
        field { desc = "Number of bits in the trace source field

Writable only while trTeControl.Enable=0."; sw = rw; } SrcBits[31:28] = 4;
    } trTeInstFeatures @ 0x008;

    // ====================================================================
    // trTeInstFilters - CTTE Instruction Filters Register @ 0x00C
    // ====================================================================
    reg {
        name = "CTTE Instruction Filters Register ";
        desc = "Defines filters for qualifying control flow CTTE generation.
                Only accessible on trTeControl. Enable=0";

        field {
            desc = "Determine which filters qualify an instruction trace

Writable only while trTeControl.Enable=0.";
            sw = rw;
        } Filters[NUM_TRACE_FILTER-1:0] = 0;
    } trTeInstFilters @ 0x00C;

    // ====================================================================
    // trTeDataControl - CTTE Data Trace Control Register @ 0x010
    // ====================================================================
    reg {
        name = "CTTE Data Trace Control Register";
        desc = "Controls data trace behavior";

        field { desc = "Read as 1 if data trace is implemented"; } DataImplemented[0:0] = 1;

        field {
            desc = "Data trace is being generated";
            sw = rw; hwclr; hwset;
        } DataTracing[1:1] = 0;

//      NOT IMPLEMENTED: CTTE has no data-trace trigger input (the single
//      external trigger input drives the INSTRUCTION trace actions of
//      trTeTrigExtInControl; TCI's trTeDataTrigEnable has no source here).
//      field { desc = "Global enable/disable for data trace triggers"; }                    DataTrigEnable[3:3]      = 0;

        field {
            desc = "Sticky status: set when data-trace messages were LOST -- either
                    because the generic eTIP drop path discarded a beat (the same
                    event that sets trTeControl.InstStallOrOverflow) or because the
                    DataDropEna policy suppressed data-trace messages at the
                    watermark. Write 1 to clear (RW1C); additionally cleared by
                    hardware while trTeControl.Enable = 0.
                    STALL HALF NOT IMPLEMENTED -- same reason as
                    trTeControl.InstStallOrOverflow: the ingress port is
                    unidirectional, so the encoder cannot stall a hart and
                    DataStallEna [4] stays unimplemented. [CTTE specific]";
            sw = rw; onwrite = woclr; hwset; hwclr;
        } DataStallOrOverflow[3:3] = 0;
//      NOT IMPLEMENTED (P7): see InstStallOrOverflow -- no hart back channel.
//      field { desc = "Enable hart stall if TE cannot send a message"; }                    DataStallEna[4:4]        = 0;

        field {
            desc = "Sticky status: set when the DataDropEna policy actually dropped
                    data-trace messages (one set event per drop episode). Write 1 to
                    clear (RW1C); additionally cleared by hardware while
                    trTeControl.Enable = 0. Reads 0 in a build without the
                    CT_EN_DF_DROP switch (nothing can set it).";
            sw = rw; onwrite = woclr; hwset; hwclr;
        } DataDrop[5:5] = 0;

        field {
            desc = "Allow dropping data trace to avoid instruction trace overflows.
                    While set, the encoder suppresses data-trace messages as soon as
                    the eTIP queue fill reaches the drop watermark
                    (ct_pkg::CT_DF_DROP_WATERMARK = 3/4 of the queue depth), so the
                    remaining capacity stays available for the instruction trace.
                    Each drop episode is announced ON THE WIRE by ONE Error message
                    (TCODE 8) with ETYPE = QueueOverrun and ECODE = 0x02
                    (DataMessageLost) -- deliberately WITHOUT the ProgramTraceSync
                    (SYNC=7) re-anchor of the generic overflow path: forcing an
                    instruction re-anchor for every dropped data message would
                    defeat the purpose of the policy.
                    RUNTIME policy, therefore NOT gated by trTeControl.Enable
                    (unlike the configuration fields): software may arm or disarm
                    the drop while the trace is running.
                    Reset 0 = never drop (byte-identical legacy behaviour); reads 0
                    and is not writable in a build without CT_EN_DF_DROP.
                    Advertised in the vendor config message as CAPS/ENAB bit 22
                    (DF_DROP).";
            sw = rw;
        } DataDropEna[6:6] = 0;
//      NOT IMPLEMENTED (AW decision E-P7-1, 2026-08-04): deferred until a customer
//      asks for it. Both bits are opt-in FORMAT VARIANTS of the data-trace message
//      (a field disappears), so they cannot be self-detected by a decoder -- each
//      would need its own CAPS/ENAB bit AND a decoder change, and DataNoAddr would
//      additionally make the P3 XOR reference and TCODE 13/14 meaningless.
//      field { desc = "Omit data values from data trace packets when set"; }                DataNoValue[16:16]       = 0;
//      field { desc = "Omit data address from data trace packets when set"; }               DataNoAddr[17:17]        = 0;

        enum trTeDataAddrCompress_e {
            DTR_ADDR_FULL     = 0 { desc = "Only send full (unmodified) addresses"; };
            DTR_ADDR_XOR      = 1 { desc = "Use XOR compression"; };
         // Modes 2/3 are NOT implemented (E-P3-2): DIFF turns negative for
         // descending addresses (stack, backwards copies) and would need a
         // sign encoding the wire format does not carry; the dynamic mode
         // is not decodable without an extra wire bit. The WARL wrapper
         // (ct_cs_cpuif_wb.sv) legalizes a 2/3 write to 0.
         // DTR_ADDR_DIFF     = 2 { desc = "Use differential compression"; };
         // DTR_ADDR_XOR_DIFF = 3 { desc = "Dynamically select XOR or differential compression"; };
        };
        field {
            desc = "Data trace address compression mode. 0 = full addresses
                    (reset; byte-identical legacy stream). 1 = XOR against the
                    previous data-trace message's address; the first DF after
                    a re-anchor event (any synchronizing message, a DataTracing
                    rising edge, any ERROR message, reset) is emitted as the
                    synchronizing TCODE 13/14 form carrying the full address.
                    Modes 2/3 are not implemented (sign/encodability, see the
                    reference manual) -- WARL: writes of 2/3 (and of 1 when the
                    CT_EN_DF_ADDR_COMPRESS build switch is 0) legalize to 0.

Writable only while trTeControl.Enable=0.";
            encode = trTeDataAddrCompress_e;
            sw = rw;
        } DataAddrCompress[19:18] = 0;

        field {
            desc = "Read as 1 if split-load tracing is implemented (sdata/lresp/ldata path).
                    Force to 1 in generated RTL when SPLIT_DATA_ACCESS parameter=1 (see ct_cs_cpuif.sv). [CTTE specific]";
            hw = w; sw = r;
        } DataSplitLoad[20:20] = 0;
    } trTeDataControl @ 0x010;

    // ====================================================================
    // trTeDataFilters - CTTE Trace Data Filters Register @ 0x01C
    // ====================================================================
    reg {
        name = "CTTE Trace Data Filters Register";
        desc = "Defines filters for qualifying data trace generation.
                Only accessible on trTeControl. Enable=0";

        field {
            desc = "Determine which filters qualify a data trace

Writable only while trTeControl.Enable=0.";
            sw = rw;
        } Filters[NUM_TRACE_FILTER-1:0] = 0;
    } trTeDataFilters @ 0x01C;

    // ====================================================================
    // trTeProtocolSel - Accemic protocol discovery @ 0x030
    // Read-only in EVERY profile and structure-stable (the field never
    // disappears). The protocol is a synthesis parameter of this encoder
    // instance (ct_encoder EN_NTRACE / EN_ETRACE), so the value is driven
    // by hardware instead of being an RDL profile constant: in a mixed SoC
    // each encoder reports its own back end. The runtime select of the
    // former dual build is retired (AW directive 2026-08-04).
    reg {
        name = "trTeProtocolSel";
        desc = "Active trace protocol: 0 = N-Trace 1.0 (Nexus), 1 = E-Trace 2.0 (te_inst). Read-only discovery of the compiled-in back end (synthesis parameter, per encoder instance).";
        field {
            desc = "Compiled-in trace protocol of this encoder instance";
            sw = r; hw = w;
        } Protocol[0:0] = 0;
    } trTeProtocolSel @ 0x030;

    // trTsControl - CTTE Timestamp Control Register @ 0x040
    // ====================================================================
    reg {
        name = "CTTE Timestamp Control Register";
        desc = "Controls the behavior of the timestamp unit";

        field {
            desc = "Primary reset/enable for timestamp unit";
            sw = rw;
        } Active[0:0] = 0;

        field {
            desc = "Internal timestamp only. 1: counter runs, 0: counter stopped";
            sw = rw;
        } Count[1:1] = 0;

        field {
            desc = "Internal timestamp only. Write 1 to reset the timestamp counter";
            sw = rw;
        } Reset[2:2] = 0;

//      field { desc = "Internal Core timestamp only. 1: counter runs when hart is halted (in debug mode), 0: stopped"; } trTsRunInDebug[3:3] = 0;

        enum trTsType_e {
            TR_TS_NONE     = 0 { desc = "No timestamp"; };
//          TR_TS_EXTERNAL = 1 { desc = "External timestamp"; };
            TR_TS_SYSTEM   = 2 { desc = "Timestamp from internal system (such as bus clock)"; };
            TR_TS_CORE     = 3 { desc = "Timestamp from internal core"; };
//          TR_TS_SHARED   = 4 { desc = "Shared timestamp"; };
//          TR_TS_VENDOR0  = 5 { desc = "Vendor-specific timestamp"; };
//          TR_TS_VENDOR1  = 6 { desc = "Vendor-specific timestamp"; };
//          TR_TS_VENDOR2  = 7 { desc = "Vendor-specific timestamp"; };
        };
        field {
            desc = "Type of Timestamp unit.
                    Only accessible on trTeControl. Enable=0";
            encode = trTsType_e;
            sw = rw;
        } Type[6:4] = 0;

        field {
            desc = "Internal timestamp only. Prescale timestamp clock by 2^2n (1, 4, 16, 64).
                    Only accessible on trTeControl. Enable=0";
            sw = rw;
        } Prescale[9:8] = 0;

        field {
            desc = "Global enable for timestamp field in trace messages/packets";
            sw = rw;
        } Enable[15:15] = 1;

        field {
            desc = "Width of timestamp in bits (0..63).
                    Only accessible on trTeControl. Enable=0";
        } Width[29:24] = 63;
    } trTsControl @ 0x040;

    // ====================================================================
    // trTsCounterLow - Timestamp Counter Register Low @ 0x048
    // ====================================================================
    reg {
        name = "Timestamp Counter Register Low";
        desc = "Stores the lower 32 bits (bits [31:0]) of the current 64-bit timestamp counter.";

        field {
            desc = "Lower 32 bits (bits [31:0]) of the timestamp counter";
            hw = w;
        } Value[31:0] = 0;
    } trTsCounterLow @ 0x048;

    // ====================================================================
    // trTsCounterHigh - Timestamp Counter Register High @ 0x04C
    // ====================================================================
    reg {
        name = "Timestamp Counter Register High";
        desc = "Stores the upper 32 bits (bits [63:32]) of the current 64-bit timestamp counter.";

        field {
            desc = "Upper 32 bits (bits [63:32]) of the timestamp counter";
            hw = w;
        } Value[31:0] = 0;
    } trTsCounterHigh @ 0x04C;

    // ====================================================================
    // Trigger configuration block (P7, RISC-V Trace Control Interface 6.2).
    // N-Trace delegates these three registers to the TCI spec ("See TCI"), so
    // the TCI tables 19/20/21 are the normative source here.
    //
    // What CTTE actually owns: ONE external trigger input -- the generic
    // tip.trigger event port of the ingress interface (rtl/pkg/tip_if.sv).
    // There is no debug-trigger interface and no trigger OUTPUT port, and
    // adding one would change the encoder's top-level signal contract. TCI
    // makes the honest answer for those explicit: "If external trigger
    // input/output #N does not exist, then its action/event bits are fixed at
    // 0" (Tables 20/21) -- a read-only 0 is the PRESCRIBED discovery answer,
    // not a stub.
    // ====================================================================

    // ====================================================================
    // trTeTrigDbgControl - Debug Trigger Control Register @ 0x050
    // ====================================================================
    reg {
        name = "Debug Trigger Control Register";
        desc = "Vendor-specific setup for RISC-V Debug-Module triggers whose action is a
                trace action (TCI Table 19). CTTE has no debug-trigger interface: the
                ingress port carries no mcontrol trigger-hit sideband, so there is
                nothing to configure. Read-only 0 in every profile; writes are ignored.
                The register is kept in the map (rather than left unmapped) so a TCI
                tool gets a defined 'no vendor trigger setup' answer instead of a bus
                error. [TCI Table 19]";
        field {
            desc = "Vendor-specific trigger setup. Fixed at 0 (no debug-trigger interface).";
            sw = r;
        } TrigDbgSetup[31:0] = 0;
    } trTeTrigDbgControl @ 0x050;

    // ====================================================================
    // trTeTrigExtInControl - External Trigger Input Control Register @ 0x054
    // ====================================================================
    reg {
        name = "External Trigger Input Control Register";
        desc = "Selects the action performed when an external trigger input fires
                (TCI Table 20). CTTE implements external trigger input #0 = the generic
                tip.trigger event port; inputs #1..7 do not exist and their action
                fields are fixed at 0 as the spec prescribes.";

        enum trTeTrigAction_e {
            TRIG_ACT_NONE   = 0 { desc = "No action"; };
         // TRIG_ACT_RES1   = 1 { desc = "Reserved"; };
            TRIG_ACT_ON     = 2 { desc = "Trace-on action: while trTeControl.InstTrigEnable = 1 the trigger starts instruction tracing (trTeInstTracing -> 1). CTTE has no trTeDataTrigEnable, so data tracing is not affected."; };
            TRIG_ACT_OFF    = 3 { desc = "Trace-off action: while trTeControl.InstTrigEnable = 1 the trigger stops instruction tracing (trTeInstTracing -> 0). CTTE has no trTeDataTrigEnable, so data tracing is not affected."; };
            TRIG_ACT_NOTIFY = 4 { desc = "Trace-notify action: while instruction tracing is active the trigger upgrades the next retire to a synchronization message with the current PC (and, if enabled, a timestamp) -- the SYNC=6 Trace-Event marker of N-Trace Table 25. Requires the CT_EN_TRIG_SYNC build switch (it IS that marker path); NOT gated by InstTrigEnable, matching the TCI text."; };
         // Actions 5..15 are reserved by TCI; the WARL wrapper legalizes them to 0.
        };
        field {
            desc = "Select action to perform when external trigger input #0 fires.
                    External trigger input #0 is the generic tip.trigger event port of
                    the ingress interface -- the same pulse that the historical
                    trTeControl.InstTrigEnable path consumes.
                    WARL: legal values are 0 (no action), 2 (trace-on), 3 (trace-off)
                    and -- only with the CT_EN_TRIG_SYNC build switch -- 4
                    (trace-notify); every other value, and any value at all in a build
                    without CT_EN_TRIG_REGS, is legalized to 0 before it reaches the
                    register (legalization lives in ct_cs_cpuif_wb.sv, not in this
                    generated block).
                    RELATION TO InstTrigEnable (documented deviation): CTTE used
                    InstTrigEnable as the enable of the SYNC=6 notify marker long
                    before this register existed, and that behaviour is UNCHANGED --
                    action 4 is an ADDITIONAL source of the same one-shot, so a
                    configuration with InstTrigEnable = 1 AND Action0 = 4 still
                    produces exactly ONE marker per trigger pulse.
                    Writable only while trTeControl.Enable = 0.";
            encode = trTeTrigAction_e;
            sw = rw;
        } ExtInAction0[3:0] = 0;

        field {
            desc = "Actions for external trigger inputs #1..7 (4 bits each, same encoding
                    as ExtInAction0). These inputs do not exist in CTTE, so per TCI
                    Table 20 their action fields are fixed at 0.";
            sw = r;
        } ExtInActionN[31:4] = 0;
    } trTeTrigExtInControl @ 0x054;

    // ====================================================================
    // trTeTrigExtOutControl - External Trigger Output Control Register @ 0x058
    // ====================================================================
    reg {
        name = "External Trigger Output Control Register";
        desc = "Bitmap selecting which events fire an external trigger OUTPUT
                (TCI Table 21). CTTE has no trigger output port -- adding one would
                change the encoder's top-level signal contract -- so per TCI Table 21
                all event bits are fixed at 0 ('If external trigger output #0 does not
                exist, then all bits are fixed at 0'). Writes are ignored.";
        field {
            desc = "Event bitmap for external trigger output #0. Fixed at 0 (output does not exist).";
            sw = r;
        } ExtOutEvent0[3:0] = 0;
        field {
            desc = "Event bitmaps for external trigger outputs #1..7. Fixed at 0 (outputs do not exist).";
            sw = r;
        } ExtOutEventN[31:4] = 0;
    } trTeTrigExtOutControl @ 0x058;

    // ====================================================================
    // trTeFilter[] - Trace Encoder Filter regfile @ 0x0400 += 0x20
    // ====================================================================
    regfile {
        name = "CTTE Trace Encoder Filter";
        desc = "Single filter configuration. Only accessible on trTeControl. Enable=0";

        reg {
            name = "Filter Control Register";
            desc = "Enable, input select, function, match mode, inversion and latching";

            field {
                desc = "Overall filter enable for filter #i

Writable only while trTeControl.Enable=0.";
                sw = rw;
            } Enable[0:0] = 0;

            field {
                desc = "When set, match privilege levels specified by
                        trTeFilterMatchChoicePrivilege field for filter #i

Writable only while trTeControl.Enable=0.";
                sw = rw;
            } MatchPrivilege[1:1] = 0;

            field {
                desc = "When set, start matching from exception cause codes specified by trTeFilterMatchChoiceEcause
                        field for filter #i, and stop matching upon return from the 1st matching exception.

Writable only while trTeControl.Enable=0.";
                sw = rw;
            } MatchEcause[2:2] = 0;

            field {
                desc = "When set, start matching from either an interrupt or exception as specified by trTeFilterMatchValueInterrupt
                        field for filter #i, and stop matching upon return from the 1st matching trap.

Writable only while trTeControl.Enable=0.";
                sw = rw;
            } MatchInterrupt[3:3] = 0;

            field {
                desc = "When set, the output of the comparator selected by trTeFilterComp1
                        must be true for the filter to match

Writable only while trTeControl.Enable=0.";
                sw = rw;
            } MatchComp1[4:4] = 0;

            field {
                desc = "Specifies the comparator unit to use for the 1st comparison.

Writable only while trTeControl.Enable=0.";
                sw = rw;
            } Comp1[7:5] = 0;

            field {
                desc = "When set, the output of the comparator selected by trTeFilterComp2
                        must be true for the filter to match

Writable only while trTeControl.Enable=0.";
                sw = rw;
            } MatchComp2[8:8] = 0;

            field {
                desc = "Specifies the comparator unit to use for the 2nd comparison.

Writable only while trTeControl.Enable=0.";
                sw = rw;
            } Comp2[11:9] = 0;

            field {
                desc = "When set, the output of the comparator selected by trTeFilterComp3
                        must be true for the filter to match

Writable only while trTeControl.Enable=0.";
                sw = rw;
            } MatchComp3[12:12] = 0;

            field {
                desc = "Specifies the comparator unit to use for the 3rd comparison

Writable only while trTeControl.Enable=0.";
                sw = rw;
            } Comp3[15:13] = 0;

            field {
                desc = "When set, match impdef values as specified by trTeFilterMatchValueImpdef
                        and trTeFilterMatchMaskImpdef fields for filter #i.

Writable only while trTeControl.Enable=0.";
                sw = rw;
            } Impdef[16:16] = 0;

            field {
                desc = "When set, match dtype values as specified by
                        trTeFilterMatchChoiceDtype field for filter #i.

Writable only while trTeControl.Enable=0.";
                sw = rw;
            } Dtype[24:24] = 0;

            field {
                desc = "When set, match dsize values as specified by
                        trTeFilterMatchChoiceDsize field for filter #i)

Writable only while trTeControl.Enable=0.";
                sw = rw;
            } Dsize[25:25] = 0;
        } Control @ 0x000;

        reg {
            name = "Filter Instruction Match Control Register";
            desc = "Privilege bitmap and interrupt/exception selector. Only accessible on trTeControl. Enable=0";

            field {
                desc = "Privilege bitmap; bit N=1 matches priv=N

Writable only while trTeControl.Enable=0.";
                sw = rw;
            } ChoicePrivilege[7:0] = 0;

            enum trTeFilterMatchInstExInt_e {
                TR_FILTER_MATCHVALUE_EXCEPTION_TRAP = 0 { desc = "exception/trap"; };
                TR_FILTER_MATCHVALUE_INTERRUPT      = 1 { desc = "interrupt"; };
            };
            field {
                desc = "Interrupt/exception selector for start condition. 0: EXCEPTION_TRAP, 1: INTERRUPT

Writable only while trTeControl.Enable=0.";
                encode = trTeFilterMatchInstExInt_e;
                sw = rw;
            } ValueInterrupt[8:8] = 0;
        } Match @ 0x004;

        reg {
            name = "Filter Ecause Match Control (low)";
            desc = "Bits 31:0 of Ecause bitmap. Only accessible on trTeControl. Enable=0.
                    Default configuration: Only Bits 0...15 are used.";

            field {
                desc = "Bitmap for ecause codes 0..31; bit N=1 matches ecause=N

Writable only while trTeControl.Enable=0.";
                sw = rw;
            } Value[31:0] = 0;
        } MatchChoiceEcauseLow @ 0x008;

        reg {
            name = "Filter Ecause Match Control (high)";
            desc = "Bits 63:32 of Ecause bitmap. Only accessible on trTeControl. Enable=0.
                    Not used in default configuration";

            field {
                desc = "Bitmap for ecause codes 32..63; bit N=1 matches ecause=N+32

Writable only while trTeControl.Enable=0.";
                sw = rw;
            } Value[31:0] = 0;
        } MatchChoiceEcauseHigh @ 0x00C;

        reg {
            name = "Filter Impdef Match Value";
            desc = "Implementation-defined value (used with mask). Only accessible on trTeControl. Enable=0";

            field {
                desc = "Value compared with (impdef & mask)

Writable only while trTeControl.Enable=0.";
                sw = rw;
            } Value[31:0] = 0;
        } MatchValueImpdef @ 0x010;

        reg {
            name = "Filter Impdef Match Mask";
            desc = "Implementation-defined mask. Only accessible on trTeControl. Enable=0";

            field {
                desc = "Mask for implementation-defined compare

Writable only while trTeControl.Enable=0.";
                sw = rw;
            } Value[31:0] = 0;
        } MatchMaskImpdef @ 0x014;

        reg {
            name = "Filter Data Match Control";
            desc = "dtype/dsize selection bitmaps. Only accessible on trTeControl. Enable=0";

            field { desc = "Bitmap for dtype; bit N=1 matches dtype=N

Writable only while trTeControl.Enable=0."; sw = rw; } Dtype[15:0]  = 0;
            field { desc = "Bitmap for dsize; bit N=1 matches dsize=N

Writable only while trTeControl.Enable=0."; sw = rw; } Dsize[23:16] = 0;
        } MatchChoiceData @ 0x018;
    } trTeFilter[NUM_TRACE_FILTER] @ 0x0400 += 0x20;

    // ====================================================================
    // trTeComp[] - Trace Encoder Comparator regfile @ 0x0600 += 0x20
    // ====================================================================
    regfile {
        name = "CTTE Trace Encoder Comparator";
        desc = "Primary/Secondary comparator pair with control and match registers.
                Only accessible on trTeControl. Enable=0";

        // Encodings as comments (tooling may turn these into enums if desired)
        // trTeCompPInput / trTeCompSInput: 0=iaddr, 1=context, 2=tval, 3=daddr
        // trTeCompPFunction (E-Trace v2.0 Table 2.6):
        //   0==,1!=,2<,3<=,4>,5>=,6=reserved (always match),7=always match
        // trTeCompSFunction (E-Trace v2.0 Table 2.6):
        //   0==,1!=,2<,3<=,4>,5>=,6=use SMatch as mask for PMatch (always match),7=always match
        // trTeCompMatchMode:
        //   0:P true, 1:P&&S, 2:!(P&&S), 3:latch on P true until instr after S true

        // 0x000: trTeCompjControl
        reg {
            name = "Comparator Control Register";
            desc = "Input select, compare functions, mode, notify";

            enum trTeCompInput_e {
                TR_COMP_INPUT_IADDR   = 0 { desc = "iaddr"; };
                TR_COMP_INPUT_CONTEXT = 1 { desc = "context"; };
                TR_COMP_INPUT_TVAL    = 2 { desc = "tval"; };
                TR_COMP_INPUT_DADDR   = 3 { desc = "daddr"; };
            };
            field { desc = "Primary input select

Writable only while trTeControl.Enable=0.";   encode = trTeCompInput_e; sw = rw; } PInput[1:0] = 0;
            field { desc = "Secondary input select

Writable only while trTeControl.Enable=0."; encode = trTeCompInput_e; sw = rw; } SInput[3:2] = 0;

            enum trTeCompPFunction_e {
                TR_COMP_PFUNC_EQUAL          = 0 { desc = "Equal to trTeCompPMatch"; };
                TR_COMP_PFUNC_NOT_EQUAL      = 1 { desc = "Not equal to trTeCompPMatch"; };
                TR_COMP_PFUNC_LESS           = 2 { desc = "Less than trTeCompPMatch"; };
                TR_COMP_PFUNC_LESS_EQUAL     = 3 { desc = "Less than or equal to trTeCompPMatch"; };
                TR_COMP_PFUNC_GREATER        = 4 { desc = "Greater than trTeCompPMatch"; };
                TR_COMP_PFUNC_GREATER_EQUAL  = 5 { desc = "Greater than or equal to trTeCompPMatch"; };
                TR_COMP_PFUNC_RESERVED_MATCH = 6 { desc = "Reserved (always match)"; };
                TR_COMP_PFUNC_ALWAYS_MATCH   = 7 { desc = "Always match"; };
            };
            enum trTeCompSFunction_e {
                TR_COMP_SFUNC_EQUAL          = 0 { desc = "Equal to trTeCompSMatch"; };
                TR_COMP_SFUNC_NOT_EQUAL      = 1 { desc = "Not equal to trTeCompSMatch"; };
                TR_COMP_SFUNC_LESS           = 2 { desc = "Less than trTeCompSMatch"; };
                TR_COMP_SFUNC_LESS_EQUAL     = 3 { desc = "Less than or equal to trTeCompSMatch"; };
                TR_COMP_SFUNC_GREATER        = 4 { desc = "Greater than trTeCompSMatch"; };
                TR_COMP_SFUNC_GREATER_EQUAL  = 5 { desc = "Greater than or equal to trTeCompSMatch"; };
                TR_COMP_SFUNC_PMASK          = 6 { desc = "Masked compare: (value AND trTeCompSMask) == trTeCompSMatch"; };
                TR_COMP_SFUNC_ALWAYS_MATCH   = 7 { desc = "Always match"; };
            };
            field { desc = "Primary function

Writable only while trTeControl.Enable=0.";   encode = trTeCompPFunction_e; sw = rw; } PFunction[6:4]  = 0;
            field { desc = "Secondary function

Writable only while trTeControl.Enable=0."; encode = trTeCompSFunction_e; sw = rw; } SFunction[10:8] = 0;

            enum trTeCompMatchMode_e {
                TR_COMP_MATCH_MODE0 = 0 { desc = "Primary result true"; };
                TR_COMP_INPUT_MODE1 = 1 { desc = "Primary and secondary result both true: (P && S)"; };
                TR_COMP_INPUT_MODE2 = 2 { desc = "Either primary or secondary result does not match: !(P && S)"; };
                TR_COMP_INPUT_MODE3 = 3 { desc = "Set when primary result is true and continue to assert until instruction after secondary result is true"; };
            };
            field {
                desc = "Match mode (0..3, see desc)

Writable only while trTeControl.Enable=0.";
                encode = trTeCompMatchMode_e;
                sw = rw;
            } MatchMode[13:12] = 0;

            field {
                desc = "Generate a trace packet explicitly reporting the address of the final instruction in a block
                        that causes a PRIMARY match. This is also known as a watchpoint.

Writable only while trTeControl.Enable=0.";
                sw = rw;
            } PNotify[14:14] = 0;

            field {
                desc = "Generate a trace packet explicitly reporting the address of the final instruction in a block
                        that causes a SECONDARY match. This is also known as a watchpoint.

Writable only while trTeControl.Enable=0.";
                sw = rw;
            } SNotify[15:15] = 0;
        } Control @ 0x000;

        reg {
            name = "Secondary Mask (low)";
            desc = "Bits 31:0 of the PMASK mask. Only accessible on trTeControl. Enable=0.
                    [CTTE specific] Used ONLY by SFunction = TR_COMP_SFUNC_PMASK, which matches
                    (value AND mask) == SMatch. Until X2a this mask was read out of
                    SMatchHigh, which made the high half of the secondary bound
                    unusable -- with 64-bit addresses SMatch{High,Low} IS the bound, so
                    the mask needs its own register.";
            field {
                desc = "Secondary mask value, bits [31:0].

Writable only while trTeControl.Enable=0.";
                sw = rw;
            } Value[31:0] = 0;
        } SMaskLow @ 0x008;

        reg {
            name = "Secondary Mask (high)";
            desc = "Bits 63:32 of the PMASK mask. Only accessible on trTeControl. Enable=0.
                    Not used in a 32-bit address configuration.";
            field {
                desc = "Secondary mask value, bits [63:32].

Writable only while trTeControl.Enable=0.";
                sw = rw;
            } Value[31:0] = 0;
        } SMaskHigh @ 0x00C;

        reg {
            name = "Primary Match (low)";
            desc = "Bits 31:0.  Only accessible on trTeControl. Enable=0";
            field {
                desc = "Primary match value, bits [31:0].

Writable only while trTeControl.Enable=0.";
                sw = rw;
            } Value[31:0] = 0;
        } PMatchLow @ 0x010;

        reg {
            name = "Primary Match (high)";
            desc = "Bits 63:32. Only accessible on trTeControl. Enable=0";
            field {
                desc = "Primary match value, bits [63:32].

Writable only while trTeControl.Enable=0.";
                sw = rw;
            } Value[31:0] = 0;
        } PMatchHigh @ 0x014;

        reg {
            name = "Secondary Match (low)";
            desc = "Bits 31:0.  Only accessible on trTeControl. Enable=0";
            field {
                desc = "Secondary match value, bits [31:0].

Writable only while trTeControl.Enable=0.";
                sw = rw;
            } Value[31:0] = 0;
        } SMatchLow @ 0x018;

        reg {
            name = "Secondary Match (high)";
            desc = "Bits 63:32. Only accessible on trTeControl. Enable=0";
            field {
                desc = "Secondary match value, bits [63:32].

Writable only while trTeControl.Enable=0.";
                sw = rw;
            } Value[31:0] = 0;
        } SMatchHigh @ 0x01C;
    } trTeComp[NUM_TRACE_COMPARATORS] @ 0x0600 += 0x20;

        // ====================================================================
        // CTTE extensions in TE vendor range (0xE00-0xFFF per N-Trace Table 3)
        // ====================================================================

        // trTeCsrControl - CSR TE Control Register @ te:0xE00 (was top-level 0x1300)
        reg {
            name = "CSR TE Control Register (access via CSR only)";
            desc = "TE control via CSR. [CTTE specific]";

            field { desc = "Do send Sync";        hw = rw; sw = r; } trTeCsrSendSync[0:0] = 0;
            field { desc = "Do send PC";          hw = rw; sw = r; } trTeCsrSendPC[1:1]   = 0;
            field { desc = "Do send TS";          hw = rw; sw = r; } trTeCsrSendTS[2:2]   = 0;
            field { desc = "Do send Clock Cycle"; hw = rw; sw = r; } trTeCsrSendCC[3:3]   = 0;
        } trTeCsrControl @ 0xE00;

        // trTeTipFifoStatus - TIP FIFO Status Register @ te:0xE04 (was top-level 0x1400)
        reg {
            name = "TIP FIFO Status Register";
            desc = "Provides TIP FIFO statistics. [CTTE specific]";

            field {
                desc = "Max fill level of internal buffering fifo since the last clear.
                        Saturates at 0x7FFF.";
                hw = w;
            } trTeTipFifoMaxFill[14:0] = 0;

            field {
                desc = "Write 1 to clear trTeTipFifoMaxFill and hold it at 0, write 0 to re-arm.";
                sw = rw;
            } trTeTipFifoMaxFillClear[15:15] = 0;

            field {
                desc = "Count of discard events (dropped message beats) since the last clear.
                        Saturates at 0x7FFF.";
                hw = w;
            } trTeTipFifoNumOverflows[30:16] = 0;

            field {
                desc = "Write 1 to clear trTeTipFifoNumOverflows and hold it at 0, write 0 to re-arm.";
                sw = rw;
            } trTeTipFifoNumOverflowsClear[31:31] = 0;
        } trTeTipFifoStatus @ 0xE04;

        // trTeSyncStatus - Sync Request Status Register @ te:0xE08
        // Diagnostic only; omitted entirely when CT_EN_SYNC_STATUS=0 (the
        // whole register drops from the address map + readback -- see the
        // ct_pkg switch). This is the register-OMISSION pattern (vs the
        // property-override `->sw=r` used elsewhere): for a register whose
        // driving unit is compiled out, dropping the definition reclaims the
        // address-decode/readback the override leaves behind.
`ifndef CT_PROFILE_NO_SYNC_STATUS
        reg {
            name = "Sync Request Status Register";
            desc = "Diagnostic status for explicit synchronization requests. On the wire
                    every explicit sync request is emitted with the single vendor SYNC
                    code 14 (explicit sync request) -- N-Trace 1.0 Table 25 reserves
                    codes 10-13 for future standard use, so the former per-source codes
                    12 (CSR) and 13 (ATB) are no longer used. The request source does
                    not matter to a decoder (every synchronization message is a full
                    re-anchor); it is kept readable here for diagnosis. [CTTE specific]";

            enum trTeSyncReqSource_e {
                SYNC_REQ_NONE  = 0 { desc = "No explicit sync request since reset"; };
                SYNC_REQ_CSR   = 1 { desc = "Most recent explicit sync request came from the traced hart itself:
                                             an ACT-CAP CF_SYNC command written to CPU CSR 0x0B10"; };
                SYNC_REQ_ATB   = 2 { desc = "Most recent explicit sync request came from the ATB sync request input"; };
                SYNC_REQ_QUOTA = 3 { desc = "Most recent explicit sync request came from a trace-quota counter
                                             overflow (InstSyncMode 1/4 threshold 2^(InstSyncMax+4) reached
                                             on the trace output)"; };
                SYNC_REQ_TE    = 4 { desc = "Most recent explicit sync request came from the control bus:
                                             a write of 1 to trTeControl.InstSyncReq (CT_EN_INST_SYNC_REQ).
                                             Kept distinct from SYNC_REQ_CSR because the requester is a
                                             different actor -- the external control/debug bus, not the
                                             traced hart"; };
            };
            field {
                desc = "Source of the most recent explicit synchronization request. [CTTE specific]";
                encode = trTeSyncReqSource_e;
                hw = w; sw = r;
            } SyncReqSource[2:0] = 0;
        } trTeSyncStatus @ 0xE08;
`endif

        // trTeTipFifoHist* - eTIP-CVS-FIFO fill-level histogram @ te:0xE10
        // 16 saturating
        // 16-bit counters; counter b increments on the UPWARD crossing of
        // fill level (b+1)*ETIP_CVS_FIFO_DEPTH/16 -- empirical FIFO sizing
        // evidence (distribution, not just the MaxFill watermark).
        // Deliberately NO CDC (counters live in tip_clk, wired straight to
        // the wb read path): READ CONTRACT -- valid only while the trace is
        // quiescent (trTeControl.Enable=0); reads during tracing may tear.
        // Omitted entirely with CT_EN_FIFO_HIST=0 (register-omission
        // pattern -- no address decode, no readback, no counters).
`ifndef CT_PROFILE_NO_FIFO_HIST
        reg {
            name = "eTIP FIFO Fill Histogram Control";
            desc = "Control for the SERIAL fill-level histogram read-out via
                    trTeTipFifoHistData. The number of bins (CT_FIFO_HIST_BINS,
                    default 16) is an RTL parameter -- the CSR map is
                    independent of it (one data register, serial pointer).
                    [CTTE specific]";
            field {
                desc = "Write 1 to clear all histogram counters AND the read
                        pointer and hold them at 0, write 0 to re-arm. Level,
                        no CDC -- change only while the trace is quiescent
                        (trTeControl.Enable=0). [CTTE specific]";
                sw = rw;
            } HistClear[0:0] = 0;
            field {
                desc = "Write 1 to rewind the serial read pointer to bin pair 0
                        WITHOUT clearing the counters (re-read the histogram).
                        Self-clearing. [CTTE specific]";
                sw = w; singlepulse;
            } RdRewind[1:1] = 0;
            field {
                desc = "Current serial read pointer (bin-pair index the next
                        trTeTipFifoHistData read will return). [CTTE specific]";
                sw = r; hw = w;
            } RdIdx[12:8] = 0;
        } trTeTipFifoHistCtrl @ 0xE10;

        reg {
            name = "eTIP FIFO Fill Histogram Data (serial read-out)";
            desc = "SERIAL window into the CT_FIFO_HIST_BINS saturating 16-bit
                    upward-crossing counters (AW: not random access -- one
                    register, DSP-backed counters, minimal readback). Each read
                    returns bin pair [2*RdIdx (Lo), 2*RdIdx+1 (Hi)] and
                    auto-increments RdIdx (wraps after BINS/2). Bin b counts
                    crossings of fill level (b+1)*DEPTH/BINS, DEPTH =
                    ETIP_CVS_FIFO_DEPTH. Read protocol: HistClear or RdRewind,
                    then BINS/2 consecutive reads. No CDC -- read only while
                    the trace is quiescent (trTeControl.Enable=0). [CTTE specific]";
            field { desc = "Bin 2*RdIdx   -- crossings of level (2*RdIdx+1)*DEPTH/BINS. [CTTE specific]"; hw = w; swacc; } Lo[15:0]  = 0;
            field { desc = "Bin 2*RdIdx+1 -- crossings of level (2*RdIdx+2)*DEPTH/BINS. [CTTE specific]"; hw = w; } Hi[31:16] = 0;
        } trTeTipFifoHistData @ 0xE14;
`endif

    } te @ 0x0000;

    // ====================================================================
    // df_mem_t - DF range filter memory entry type (64-bit)
    // ====================================================================
    mem df_mem_t {
        memwidth   = 64;
        mementries = NUM_DF_RANGE;

        // Update the entire table with tracing disabled (trTeControl.Enable=0),
        // keys strictly ascending and non-overlapping across entries -- the
        // same rule trWpDataHigh states for the watchpoint table, and for the
        // same reason: both feed a vector_binary_search tree
        // (ct_L23_preproc_df_range.sv:88). A table changed mid-trace would
        // produce undefined matches, and not only for the entry written: an
        // out-of-order key at an inner node sends every concurrent lookup down
        // the wrong branch. The lock is HARDWARE-enforced in the wrapper
        // (ct_cs_cpuif_wb.sv, mem1_wr_allowed) because SystemRDL swwel applies
        // to fields, not to a mem; a write at Enable=1 is acknowledged and
        // discarded, exactly like a swwel-locked field write (U10 F-3).
        reg {
            name = "DF Range Filter Key0 (low bound)";
            desc = "Lower 32-bit word of a 64-bit DF range-filter entry. Holds Key0, the
                    inclusive low bound of the data-address range (Key0 <= daddr <= Key1).
                    Writable only while trTeControl.Enable=0 (wrapper-enforced; keys must
                    stay sorted and non-overlapping). [CTTE specific]";

            field { sw = rw; } Value[31:0] = 0;
        } Key0 @ 0x0;

        reg {
            name = "DF Range Filter Key1 (high bound)";
            desc = "Upper 32-bit word of a 64-bit DF range-filter entry. Holds Key1, the
                    inclusive high bound of the data-address range (Key0 <= daddr <= Key1).
                    Writable only while trTeControl.Enable=0 (wrapper-enforced; the write of
                    this word is what commits the pair). [CTTE specific]";

            field { sw = rw; } Value[31:0] = 0;
        } Key1 @ 0x4;
    };

    // ====================================================================
    // wp - Watchpoints component @ 0x4000 (CTTE, vendor CompType=0x4)
    // SystemRDL does not allow 'mem' instantiations inside a regfile, so the
    // stubs and the external memory live as siblings in the same 4 KB window.
    // ====================================================================
    reg {
        name = "Watchpoints Control Register";
        desc = "Primary activate/reset for the Watchpoints component. [CTTE specific]";
        field {
            desc = "Primary activate/reset bit.
                    [Not implemented: read-only constant 1; there is no clock-gate/power-down control behind it.]";
            sw = r;
        } Active[0:0] = 1;
    } trWpControl @ 0x4000;

    reg {
        name = "Watchpoints Implementation Register";
        desc = "Version and component type information for the Watchpoints component. [CTTE specific]";
        field { desc = "Component Major Version"; } VerMajor[3:0]      = 1;
        field { desc = "Component Minor Version"; } VerMinor[7:4]      = 0;
        field { desc = "Component Type (vendor: 0x4)"; } CompType[11:8] = 0x4;
    } trWpImpl @ 0x4004;

    reg {
        name = "Watchpoint Message Mask Register";
        desc = "Enable mask for Watchpoint messages (Nexus TCODE 15). [CTTE specific]";
        field {
            desc = "Watchpoint Event Mask: one bit per reportable watchpoint slot.
                    A 1 ENABLES reporting of that bit (IEEE-ISTO 5001 Table B-26,
                    'WEM ... 1 = enabled'). NOTE: the prose of ISTO 4.3.23 says the
                    WPHIT field is 'masked by 1', which reads like the inverse; CTTE
                    follows Table B-26.
                    The emitted WPHIT of an ACT_CAP_ST_WATCHPOINT command is
                    Cmd.DirectData[15:0] AND WEM, so which slot owns which bit is a
                    SOFTWARE convention: program the watchpoints[] entry with the
                    DirectData bit you want to see and enable that bit here. A
                    command whose masked result is 0 emits no message.
                    Reset 0 masks every hit, so adding the feature to an existing
                    build changes no wire byte until software opts in. Writable only
                    while trTeControl.Enable=0. Requires the CT_EN_WATCHPOINT_MSG
                    build switch (which itself requires CT_EN_ACT); profiles without
                    the feature read 0.";
            sw = rw;
        } WEM[15:0] = 0;
    } trWpMask @ 0x4008;

    // ====================================================================
    // Indirect watchpoint table access (C0b)
    //
    // BREAKING CHANGE against the historical map: the direct 64-bit
    // memory window at 0x4100 is GONE. With NUM_ACT_ST = 1023 the array
    // spans 0x4100-0x60F7 and overlaps the df component at 0x5000
    // (PeakRDL refuses the map), and widening the 15-bit register space
    // would drag the twin CSR block and every integrator window with it.
    // The table is loaded and read back through the index/data registers
    // below instead (same serial-pointer pattern as trTeTipFifoHistData);
    // trWpCap tells software the implemented capacity.
    // ====================================================================
    reg {
        name = "Watchpoints Index Register";
        desc = "Slot index for the indirect watchpoint load/readback path.
                A trWpDataHigh write commits the staged entry to slot Idx and
                then increments Idx; a trWpReadHigh read returns the shadow
                entry at Idx and also increments it. Both wrap from
                NUM_ACT_ST-1 back to 0. Software normally writes the start
                slot once and streams NUM_ACT_ST Low/High pairs. Reads return
                the CURRENT index, so after a burst of n commits starting at
                i the register reads (i + n) mod NUM_ACT_ST -- cheap load
                verification. Values >= NUM_ACT_ST are out of range: hardware
                uses the low address bits and the first increment normalizes
                to 0. The one in-window out-of-range value, Idx = NUM_ACT_ST
                (= 1023), addresses the physical padding slot behind the last
                tree node: a commit or readback there is inert for matching
                (the search never visits that slot) and the following
                increment wraps to 0. Writable only while
                trTeControl.Enable=0. [CTTE specific]";
        field {
            desc = "Watchpoint slot index the next commit/readback targets. [CTTE specific]";
            sw = rw; hw = rw; we;
        } Idx[15:0] = 0;
    } trWpIndex @ 0x400C;

    reg {
        name = "Watchpoint Data Low (Addr staging)";
        desc = "Address (PC) that arms the watchpoint entry being staged. When
                the retired CPU PC matches Addr, the Cmd committed with it is
                dispatched through the CTTE unit. Write Low first, then
                trWpDataHigh -- the High write commits the pair to slot
                trWpIndex.Idx; a Low write alone has no effect. Writable only
                while trTeControl.Enable=0. [CTTE specific]";
        field { desc = "Addr (PC) to stage. [CTTE specific]"; sw = rw; } Value[31:0] = 0;
    } trWpDataLow @ 0x4010;

    reg {
        name = "Watchpoint Data High (Cmd staging + COMMIT)";
        desc = "Command of the watchpoint entry being staged. Writing this
                register COMMITS {trWpDataLow, this word} to slot
                trWpIndex.Idx and increments Idx -- identical commit semantics
                to the historical +0x4 write of the removed 0x4100 window.
                Bit layout is shared with RISC-V CSR 0x0B10 (ACT-CAP
                protocol), which the CPU can write directly to dispatch the
                same command immediately without going through the table.
                Writable only while trTeControl.Enable=0 (the lock also
                suppresses the commit).

                Rules for programming the table:

                  1. Fill ALL NUM_ACT_ST slots (trWpCap.Entries). Unused
                     slots are not optional — leaving a slot at its reset
                     value can mask real watchpoints.
                  2. Addr values across slot 0 .. slot NUM_ACT_ST-1 must be
                     strictly ascending and unique (Addr[i] < Addr[i+1]).
                  3. Each slot is a pair: write trWpDataLow first, then this
                     register. The High write is what commits the entry.
                  4. Update the entire table with tracing disabled
                     (trTeControl.Enable = 0). The index/staging registers
                     are hardware-locked while enabled; a table changed
                     mid-trace would produce undefined matches.

                  5. Watchpoint messages (Cmd = ACT_CAP_ST_WATCHPOINT, Nexus
                     TCODE 15): which BIT of the on-wire WPHIT field stands
                     for which slot is a SOFTWARE convention, not hardware.
                     Put the bit you want to see into that slot's
                     DirectData[15:0] (one-hot is the obvious choice) and
                     enable the same bit in trWpMask.WEM; the encoder emits
                     WPHIT = DirectData[15:0] AND WEM and stays silent when
                     that is 0.

                For slots you do not need as real watchpoints, pick an Addr
                the CPU will never execute (odd instruction addresses are
                ideal — the core forces PC[0] = 0, so odd Addr values never
                match) and set Cmd = ACT_CAP_ST_NONE. The Addr values of such
                padding slots still have to satisfy rule 2. [CTTE specific]";
        // No `encode=` on Cmd/Sink: the enum types live in the types
        // package as anchors of the hidden trActCapStCmd register (CSR
        // 0x0B10 mirror), and a second regblock-emitted copy collides in
        // every module that wildcard-imports both packages. Values are
        // trActCapStCmd_e / trActCapStSink_e.
        field { desc = "HSI command (trActCapStCmd_e). A write commits the staged pair. [CTTE specific]";
                sw = rw; swmod; } Cmd[5:0]  = 0;
        field { desc = "Sink (trActCapStSink_e)"; sw = rw; } Sink[7:6] = 0;
        field {
            desc = "Direct data (24 bits). Always included in the DAQ message payload.
                    A value of 0 is cost-free: Nexus MDO/MSEO variable-length encoding
                    strips leading zeros, so an all-zero field adds no MDO cycles.";
            sw = rw;
        } DirectData[31:8] = 0;
    } trWpDataHigh @ 0x4014;

    reg {
        name = "Watchpoint Readback Low (Addr at Idx)";
        desc = "Addr word of the shadow entry at trWpIndex.Idx. The shadow is
                zero-initialized at configuration load and NOT cleared by a
                soft reset — it reflects everything committed since
                configuration, the same persistence the search-tree memory
                itself has. Reading this register does not move Idx. [CTTE specific]";
        field { desc = "Shadow Addr at Idx. [CTTE specific]"; sw = r; hw = w; } Value[31:0] = 0;
    } trWpReadLow @ 0x4018;

    reg {
        name = "Watchpoint Readback High (Cmd at Idx, serial)";
        desc = "Cmd word of the shadow entry at trWpIndex.Idx. Reading this
                register increments Idx (wrap at NUM_ACT_ST-1) — serial
                readback: set Idx once, then alternate trWpReadLow /
                trWpReadHigh per slot. [CTTE specific]";
        field { desc = "Shadow Cmd at Idx — reading increments Idx. [CTTE specific]";
                hw = w; swacc; sw = r; } Cmd[5:0] = 0;
        field { desc = "Shadow Sink at Idx. [CTTE specific]";      hw = w; sw = r; } Sink[7:6] = 0;
        field { desc = "Shadow DirectData at Idx. [CTTE specific]"; hw = w; sw = r; } DirectData[31:8] = 0;
    } trWpReadHigh @ 0x401C;

    reg {
        name = "Watchpoints Capacity Register";
        desc = "Number of implemented watchpoint slots (NUM_ACT_ST) — software
                discovery for the indirect load path. Profiles without the ACT
                blocks read 0. [CTTE specific]";
        field { desc = "Implemented watchpoint slots. [CTTE specific]"; sw = r; } Entries[15:0] = NUM_ACT_ST;
    } trWpCap @ 0x4020;

    // ====================================================================
    // df - DF range filter component @ 0x5000 (CTTE, vendor CompType=0x5)
    // SystemRDL does not allow 'mem' instantiations inside a regfile, so the
    // stubs and the external memory live as siblings. df logically spans
    // 0x5000-0x7FFF (stubs in the first 4 KB, mem starts at 0x6000; the
    // memory occupies NUM_DF_RANGE * 8 bytes within that window).
    // ====================================================================
    reg {
        name = "DF RangeFilter Control Register";
        desc = "Primary activate/reset for the DF RangeFilter component. [CTTE specific]";
        field {
            desc = "Primary activate/reset bit.
                    [Not implemented: read-only constant 1; there is no clock-gate/power-down control behind it.]";
            sw = r;
        } Active[0:0] = 1;
    } trDfControl @ 0x5000;

    reg {
        name = "DF RangeFilter Implementation Register";
        desc = "Version and component type information for the DF RangeFilter component. [CTTE specific]";
        field { desc = "Component Major Version"; } VerMajor[3:0]      = 1;
        field { desc = "Component Minor Version"; } VerMinor[7:4]      = 0;
        field { desc = "Component Type (vendor: 0x5)"; } CompType[11:8] = 0x5;
    } trDfImpl @ 0x5004;

    external df_mem_t mem1 @ 0x6000;
    mem1->name = "DF RangeFilter Memory";
    mem1->sw = rw;
    mem1->desc = "Read/write DF range filter memory. Each 64-bit entry is a {Key1, Key0}
                  pair with Key0 <= daddr <= Key1. Software writes/reads the lower 32-bit
                  Key0 word first, then the upper 32-bit Key1 word. Memory has NUM_DF_RANGE
                  entries (sized to match the hardware binary-search tree depth
                  M1_DIM; 15 entries for the current M1_DIM=4 configuration). [CTTE specific]";


    // ====================================================================
    // pc - Performance Counter sub-component @ 0x3000 (vendor, 4 KB)
    // CTTE extension for per-region instruction/data access counters.
    // CompType=0x3 (Accemic vendor-assigned). Paths hwif_*.pc.XxxYyy.
    // ====================================================================
    regfile {
        name = "Performance Counters";
        desc = "Performance Counter sub-component (CTTE, vendor CompType=0x3). [CTTE specific]";
        default regwidth = 32;
        default sw = r;
        default hw = r;

        // Required stub: tr??Control
        reg {
            name = "PerfCounter Control Register";
            desc = "Primary activate/reset for the Performance Counter component. [CTTE specific]";
            field {
                desc = "Primary activate/reset bit.
                    [Not implemented: read-only constant 1; there is no clock-gate/power-down control behind it.]";
                sw = r;
            } Active[0:0] = 1;
        } trPcControl @ 0x000;

        // Required stub: tr??Impl
        reg {
            name = "PerfCounter Implementation Register";
            desc = "Version and component type information for the Performance Counter component. [CTTE specific]";
            field { desc = "Component Major Version"; } VerMajor[3:0]      = 1;
            field { desc = "Component Minor Version"; } VerMinor[7:4]      = 0;
            field { desc = "Component Type (vendor: 0x3)"; } CompType[11:8] = 0x3;
        } trPcImpl @ 0x004;

        // ================================================================
        // trTeConstants - CTTE Implementation Parameters (was 0x2000)
        // ================================================================
        reg {
            name = "CTTE Implementation Parameters";
            desc = "Implementatopn parameters for synchronization with RDL implementation. (RDL has no direct access PeakRDL parameters.) [CTTE specific]";

            field { desc = "NUM_TRACE_FILTER";              } num_trace_filter              [ 4: 0] = NUM_TRACE_FILTER;
            field { desc = "NUM_TRACE_COMPARATORS";         } num_trace_comparators         [ 8: 5] = NUM_TRACE_COMPARATORS;
            field { desc = "NUM_PERFCNT_IFETCH_TH_RANGES";  } num_perfcnt_ifetch_th_ranges  [12: 9] = NUM_PERFCNT_IFETCH_TH_RANGES;
            field { desc = "NUM_PERFCNT_DATA_RD_TH_RANGES"; } num_perfcnt_data_rd_th_ranges [16:13] = NUM_PERFCNT_DATA_RD_TH_RANGES;
            field { desc = "NUM_PERFCNT_DATA_RD_RANGES";    } num_perfcnt_data_rd_ranges    [20:17] = NUM_PERFCNT_DATA_RD_RANGES;
            field { desc = "NUM_PERFCNT_DATA_WR_RANGES";    } num_perfcnt_data_wr_ranges    [24:21] = NUM_PERFCNT_DATA_WR_RANGES;
        } trTeConstants @ 0x008;

        // ================================================================
        // trPerfCntControl - Encoder Perf Counter Ctrl Register (was 0x2004)
        // ================================================================
        reg {
            name = "Encoder Perf Counter Ctrl Register";
            desc = "Control register for the encoder's performance counter. [CTTE specific]";

            field {
                desc = "CPU cycles threshold for instruction fetch.
                        When required CPU clock cycles exceed this threshold, the respective counter increments.";
                sw = rw;
            } IFetchThreshold[7:0] = 4;

            field {
                desc = "CPU cycles threshold.
                        When required CPU clock cycles exceed this threshold, the respective counter increments.";
                sw = rw;
            } DataWrThreshold[15:8] = 4;
        } trPerfCntControl @ 0x010;

        // ================================================================
        // Instruction fetch ranges exceeding threshold (was 0x2100)
        // ================================================================
        regfile {
            name = "Instruction Fetch Exceeding Threshold Ranges";
            desc = "Instruction address ranges for instruction fetch events exceeding CPU cycle threshold (trPcIFetchThreshold).
                    Each entry contains the inclusive low and high address of the monitored range. [CTTE specific]";

            reg {
                name = "IFetch Range Threshold Low register";
                desc = "Inclusive low address of instruction fetch range.";
                field { desc = "Start address of the range (inclusive).

Writable only while trTeControl.Enable=0."; sw = rw; } Value[31:0] = 0;
            } Low  @ 0x0000;

            reg {
                name = "IFetch Range Threshold High register";
                desc = "Inclusive high address of instruction fetch range.";
                field { desc = "End address of the range (inclusive).

Writable only while trTeControl.Enable=0.";   sw = rw; } Value[31:0] = 0;
            } High @ 0x0004;
        } trTePerfCntIFetchRange[NUM_PERFCNT_IFETCH_TH_RANGES] @ 0x100;

        // ================================================================
        // Data read accesses exceeding threshold ranges (was 0x2200)
        // ================================================================
        regfile {
            name = "Data Read Accesses Exceeding Threshold Ranges";
            desc = "Data address ranges for data read accesses exceeding cycle threshold (trPcDataRdThreshold).
                    Each entry specifies the low and high addresses bounding the monitored range. [CTTE specific]";

            reg {
                name = "Data Read Threshold Range Low register";
                desc = "Inclusive low address of data read range.";
                field { desc = "Start address of the range (inclusive).

Writable only while trTeControl.Enable=0."; sw = rw; } Value[31:0] = 0;
            } Low  @ 0x0000;

            reg {
                name = "Data Read Threshold High register";
                desc = "High address of data write threshold range.";
                field { desc = "End address of the range (inclusive).

Writable only while trTeControl.Enable=0.";   sw = rw; } Value[31:0] = 0;
            } High @ 0x0004;
        } trTePerfCntDataRdThRange[NUM_PERFCNT_DATA_RD_TH_RANGES] @ 0x200;

        // ================================================================
        // Data read count ranges (was 0x2300)
        // ================================================================
        regfile {
            name = "Data Read Count Ranges";
            desc = "Data address ranges for data read accesses to be counted.
                    Each entry specifies the low and high addresses bounding the monitored range. [CTTE specific]";

            reg {
                name = "Data Read Count Range Low register";
                desc = "Low address of data read range.";
                field { desc = "Start address of the range (inclusive).

Writable only while trTeControl.Enable=0."; sw = rw; } Value[31:0] = 0;
            } Low  @ 0x0000;

            reg {
                name = "Data Read Count Range High register";
                desc = "High address of data write range.";
                field { desc = "End address of the range (inclusive).

Writable only while trTeControl.Enable=0.";   sw = rw; } Value[31:0] = 0;
            } High @ 0x0004;
        } trTePerfCntDataRdRange[NUM_PERFCNT_DATA_RD_RANGES] @ 0x300;

        // ================================================================
        // Data write count ranges (was 0x2400)
        // ================================================================
        regfile {
            name = "Data Write Count Ranges";
            desc = "Data address ranges for data write accesses to be counted.
                    Each entry specifies the low and high addresses bounding the monitored range. [CTTE specific]";

            reg {
                name = "Data Write Count Range Low register";
                desc = "Low address of data write range.";
                field { desc = "Start address of the range (inclusive).

Writable only while trTeControl.Enable=0."; sw = rw; } Value[31:0] = 0;
            } Low  @ 0x0000;

            reg {
                name = "Data Write Count Range High register";
                desc = "High address of data write range.";
                field { desc = "End address of the range (inclusive).

Writable only while trTeControl.Enable=0.";   sw = rw; } Value[31:0] = 0;
            } High @ 0x0004;
        } trTePerfCntDataWrRange[NUM_PERFCNT_DATA_WR_RANGES] @ 0x400;

    } pc @ 0x3000;

    // ====================================================================
    // atb - Trace ATB Bridge sub-component @ 0x1000 (N-Trace compliant, 4 KB)
    // Matches the spec's trAtbBridge?? register layout (RISC-V Trace Control
    // Interface Spec, Tables 56/57). CompType=0xE (TRCOMP_ATBBRIDGE).
    // Paths are hwif_*.atb.trAtbBridgeXxx.
    // ====================================================================
    regfile {
        name = "Trace ATB Bridge";
        desc = "Trace ATB Bridge sub-component (N-Trace compliant, CompType=0xE).
                See RISC-V N-Trace Control Interface spec Chapter 10 (Tables 56/57).";
        default regwidth = 32;
        default sw = r;
        default hw = r;

        // Table 56
        reg {
            name = "ATB Bridge Control Register";
            desc = "Primary control register for the ATB Bridge.";

            field {
                desc = "Primary activate/reset for the ATB Bridge. When 0, the ATB Bridge
                        may have clocks gated off or be powered down, and other register
                        locations may be inaccessible.
                        [Not implemented: read-only constant 1; there is no clock-gate/power-down control behind it.]";
                sw = r;
            } Active[0:0] = 1;

            field {
                desc = "1: ATB Bridge enabled. Setting Enable to 0 flushes any queued trace
                        data to ATB.";
                sw = r;
            } Enable[1:1] = 1;

            field {
                desc = "Reads as 1 when ATB Bridge internal buffers are empty.";
                hw = w;
            } Empty[3:3] = 1;

            // The ATID values 0x00, 0x70-0x7C, 0x7E, and 0x7F are reserved for use by
            // the CoreSight Architecture and must not be used as ATB IDs.
            field {
                desc = "ID of this node on ATB. Values 0x00 and 0x70-0x7F are reserved by
                        the ATB specification and should not be used.

Writable only while trTeControl.Enable=0.";
                sw = rw;
            } ID[14:8] = 8;
        } trAtbBridgeControl @ 0x000;

        // Table 57
        reg {
            name = "ATB Bridge Implementation Register";
            desc = "Contains version and protocol information for the ATB Bridge.";

            field { desc = "ATB Bridge Component Major Version";   } VerMajor[3:0]      = 1;
            field { desc = "ATB Bridge Component Minor Version";   } VerMinor[7:4]      = 0;
            field { desc = "ATB Bridge Component Type (0xE)";      } CompType[11:8]     = 0xE;
            field {
                desc = "Async packet frequency. 0: Async disabled; 1..7: different levels
                        of alignment synchronization.

Writable only while trTeControl.Enable=0.";
                sw = rw;
            } AsyncFreq[14:12] = 0;
        } trAtbBridgeImpl @ 0x004;
    } atb @ 0x1000;

    // ====================================================================
    // Dynamic property assignments: swwel gating
    // ====================================================================
    // Every configuration field listed below becomes software-writable only
    // while te.trTeControl.Enable == 0. PeakRDL-regblock honours the
    // `swwel = <field>` reference and generates the internal write gate, so
    // no manual `hwif_in.*.swwe` plumbing is needed in ct_cs_cpuif_wb.sv.
    //
    // Not gated (intentionally always writable). The list is COMPLETE and is
    // checked as such: scripts/check_swwel_census.py counts the write gates in
    // the generated block and fails if a field is ungated without standing
    // here (U10 F-2 — the list used to name 10 of the then 31 ungated fields,
    // so "not in the list" carried no information at all).
    //
    //   Session control — the run/stop handles themselves; gating them on
    //   Enable would be circular:
    //   - te.trTeControl.{Active,Enable,InstTracing,InstSyncReq}
    //   - te.trTeDataControl.DataTracing (the data channel's own run/stop)
    //
    //   Status clear / read-out, must work mid-session or the status is
    //   unusable:
    //   - te.trTeTipFifoStatus.{trTeTipFifoMaxFillClear,trTeTipFifoNumOverflowsClear}
    //   - te.trTeTipFifoHistCtrl.{HistClear,RdRewind} — the histogram is a
    //     diagnostic side channel; clearing/rewinding it touches no encoder
    //     state (HistClear's own description asks for a quiescent trace, that
    //     is operator advice about the counter values, not a format hazard).
    //   - the RW1C status bits te.trTeControl.InstStallOrOverflow and
    //     te.trTeDataControl.{DataStallOrOverflow,DataDrop} (P7) — same class:
    //     software must be able to clear them mid-session.
    //
    //   Runtime POLICY, not configuration — no format state, no re-anchor:
    //   - te.trTeDataControl.DataDropEna (P7): arming/disarming the
    //     data-trace drop while the trace runs changes no format.
    //   - pc.trPerfCntControl.{IFetchThreshold,DataWrThreshold} (U10 F-2):
    //     the two ACT stall thresholds. They are compared COMBINATIONALLY
    //     against a counter that restarts at every retire
    //     (rtl/preproc/ct_L23_preproc_perfcnt.sv:81-122,193,222), so a new
    //     value simply applies from the next measurement window on — no
    //     cross-window state can go stale, and the counters they feed leave
    //     the encoder as ACT counter values, never as instruction-trace
    //     grammar. The perfcnt ADDRESS RANGES right below ARE gated, and the
    //     asymmetry is deliberate: a range is two registers (Low + High), so
    //     a mid-trace update is visible for one bus cycle as a nonsense
    //     interval made of the new Low and the old High. A single-field
    //     scalar cannot be torn that way.
    //
    //   Message-class enables whose messages are self-identifying by TCODE:
    //   - te.trTeControl.{SendConfig,Context,InstSeqSyncEnable,InstTrigEnable}
    //     — switching these mid-session adds or removes whole messages
    //     (TCODE 58 / TCODE 2 / extra syncs), which a decoder handles by
    //     TCODE; it does not re-interpret the fields of other messages.
    //     Contrast trTeInstFeatures.InstEn*, which change how the SAME
    //     message is encoded and are therefore locked (F-1 below).
    //   - te.trTsControl.{Active,Count,Reset,Enable}: the timestamp unit's
    //     own run control. CAVEAT, stated because it is the one entry here
    //     with a wire-visible effect: clearing trTsControl.Enable mid-session
    //     removes the TSTAMP field from subsequent messages, which a decoder
    //     started with timestamps does not expect. Kept writable because
    //     start/stop/reset of the TS counter is the register's purpose; the
    //     programming order in doc/integration.adoc covers it.
    //
    // Arrays collapse to a single assignment (applied to every instance).
    // ====================================================================

    // trTeControl fields (self-gated by sibling Enable)
    // (te.trTeProtocolSel.Protocol needs no swwel gate -- it is read-only
    // discovery of a synthesis parameter, P9.)
    te.trTeControl.InstMode         ->swwel = te.trTeControl.Enable;
    te.trTeControl.InhibitSrc       ->swwel = te.trTeControl.Enable;
    te.trTeControl.InstSyncMode     ->swwel = te.trTeControl.Enable;
    te.trTeControl.InstSyncMax      ->swwel = te.trTeControl.Enable;

    // Other te scalars
    te.trTeInstFeatures.SrcID       ->swwel = te.trTeControl.Enable;
    te.trTeInstFeatures.SrcBits     ->swwel = te.trTeControl.Enable;
`ifndef CT_PROFILE_NO_TIMESTAMP
    te.trTsControl.Type             ->swwel = te.trTeControl.Enable;
    te.trTsControl.Prescale         ->swwel = te.trTeControl.Enable;
`endif

    // ----------------------------------------------------------------
    // Filter/comparator group: gated by the CT_EN_FILTERS build switch.
    // Compiled out -> all config fields become sw=r constants (reset 0).
    // ----------------------------------------------------------------
`ifdef CT_PROFILE_NO_FILTERS
    te.trTeInstFilters.Filters                ->sw = r;
    te.trTeFilter.Control.Enable              ->sw = r;
    te.trTeFilter.Control.MatchPrivilege      ->sw = r;
    te.trTeFilter.Control.MatchEcause         ->sw = r;
    te.trTeFilter.Control.MatchInterrupt      ->sw = r;
    te.trTeFilter.Control.MatchComp1          ->sw = r;
    te.trTeFilter.Control.Comp1               ->sw = r;
    te.trTeFilter.Control.MatchComp2          ->sw = r;
    te.trTeFilter.Control.Comp2               ->sw = r;
    te.trTeFilter.Control.MatchComp3          ->sw = r;
    te.trTeFilter.Control.Comp3               ->sw = r;
    te.trTeFilter.Control.Impdef              ->sw = r;
    te.trTeFilter.Control.Dtype               ->sw = r;
    te.trTeFilter.Control.Dsize               ->sw = r;
    te.trTeFilter.Match.ChoicePrivilege       ->sw = r;
    te.trTeFilter.Match.ValueInterrupt        ->sw = r;
    te.trTeFilter.MatchChoiceEcauseLow.Value  ->sw = r;
    te.trTeFilter.MatchChoiceEcauseHigh.Value ->sw = r;
    te.trTeFilter.MatchValueImpdef.Value      ->sw = r;
    te.trTeFilter.MatchMaskImpdef.Value       ->sw = r;
    te.trTeFilter.MatchChoiceData.Dtype       ->sw = r;
    te.trTeFilter.MatchChoiceData.Dsize       ->sw = r;
    te.trTeComp.Control.PInput                ->sw = r;
    te.trTeComp.Control.SInput                ->sw = r;
    te.trTeComp.Control.PFunction             ->sw = r;
    te.trTeComp.Control.SFunction             ->sw = r;
    te.trTeComp.Control.MatchMode             ->sw = r;
    te.trTeComp.Control.PNotify               ->sw = r;
    te.trTeComp.Control.SNotify               ->sw = r;
    te.trTeComp.PMatchLow.Value               ->sw = r;
    te.trTeComp.PMatchHigh.Value              ->sw = r;
    te.trTeComp.SMatchLow.Value               ->sw = r;
    te.trTeComp.SMatchHigh.Value              ->sw = r;
    te.trTeComp.SMaskLow.Value                ->sw = r;
    te.trTeComp.SMaskHigh.Value               ->sw = r;
`else
    te.trTeInstFilters.Filters      ->swwel = te.trTeControl.Enable;

    // trTeFilter[NUM_TRACE_FILTER] — one dynamic assignment per field covers all instances
    te.trTeFilter.Control.Enable              ->swwel = te.trTeControl.Enable;
    te.trTeFilter.Control.MatchPrivilege      ->swwel = te.trTeControl.Enable;
    te.trTeFilter.Control.MatchEcause         ->swwel = te.trTeControl.Enable;
    te.trTeFilter.Control.MatchInterrupt      ->swwel = te.trTeControl.Enable;
    te.trTeFilter.Control.MatchComp1          ->swwel = te.trTeControl.Enable;
    te.trTeFilter.Control.Comp1               ->swwel = te.trTeControl.Enable;
    te.trTeFilter.Control.MatchComp2          ->swwel = te.trTeControl.Enable;
    te.trTeFilter.Control.Comp2               ->swwel = te.trTeControl.Enable;
    te.trTeFilter.Control.MatchComp3          ->swwel = te.trTeControl.Enable;
    te.trTeFilter.Control.Comp3               ->swwel = te.trTeControl.Enable;
    te.trTeFilter.Control.Impdef              ->swwel = te.trTeControl.Enable;
    te.trTeFilter.Control.Dtype               ->swwel = te.trTeControl.Enable;
    te.trTeFilter.Control.Dsize               ->swwel = te.trTeControl.Enable;
    te.trTeFilter.Match.ChoicePrivilege       ->swwel = te.trTeControl.Enable;
    te.trTeFilter.Match.ValueInterrupt        ->swwel = te.trTeControl.Enable;
    te.trTeFilter.MatchChoiceEcauseLow.Value  ->swwel = te.trTeControl.Enable;
    te.trTeFilter.MatchChoiceEcauseHigh.Value ->swwel = te.trTeControl.Enable;
    te.trTeFilter.MatchValueImpdef.Value      ->swwel = te.trTeControl.Enable;
    te.trTeFilter.MatchMaskImpdef.Value       ->swwel = te.trTeControl.Enable;
    te.trTeFilter.MatchChoiceData.Dtype       ->swwel = te.trTeControl.Enable;
    te.trTeFilter.MatchChoiceData.Dsize       ->swwel = te.trTeControl.Enable;

    // trTeComp[NUM_TRACE_COMPARATORS]
    te.trTeComp.Control.PInput      ->swwel = te.trTeControl.Enable;
    te.trTeComp.Control.SInput      ->swwel = te.trTeControl.Enable;
    te.trTeComp.Control.PFunction   ->swwel = te.trTeControl.Enable;
    te.trTeComp.Control.SFunction   ->swwel = te.trTeControl.Enable;
    te.trTeComp.Control.MatchMode   ->swwel = te.trTeControl.Enable;
    te.trTeComp.Control.PNotify     ->swwel = te.trTeControl.Enable;
    te.trTeComp.Control.SNotify     ->swwel = te.trTeControl.Enable;
    te.trTeComp.PMatchLow.Value     ->swwel = te.trTeControl.Enable;
    te.trTeComp.PMatchHigh.Value    ->swwel = te.trTeControl.Enable;
    te.trTeComp.SMatchLow.Value     ->swwel = te.trTeControl.Enable;
    te.trTeComp.SMatchHigh.Value    ->swwel = te.trTeControl.Enable;
    te.trTeComp.SMaskLow.Value      ->swwel = te.trTeControl.Enable;
    te.trTeComp.SMaskHigh.Value     ->swwel = te.trTeControl.Enable;
`endif

    // ----------------------------------------------------------------
    // Data-trace group: gated by the CT_EN_DATA_TRACE build switch.
    // DataImplemented additionally reads 0 (feature absent); DataTracing
    // keeps its hwset/hwclr inputs (wrapper CDC stays wired) but loses
    // the SW write path.
    // ----------------------------------------------------------------
`ifdef CT_PROFILE_NO_DATA_TRACE
    te.trTeDataControl.DataImplemented  ->reset = 0;
    te.trTeDataControl.DataTracing      ->sw = r;
    te.trTeDataControl.DataAddrCompress ->sw = r;
    te.trTeDataControl.DataDropEna      ->sw = r;
    te.trTeDataFilters.Filters          ->sw = r;
`else
`ifdef CT_PROFILE_NO_DF_DROP
    // Data-trace drop policy compiled out (CT_EN_DF_DROP = 0): the policy bit
    // is a read-only constant 0 -- nothing can drop, nothing can set DataDrop.
    te.trTeDataControl.DataDropEna      ->sw = r;
`endif
`ifdef CT_PROFILE_NO_DF_ADDR_COMPRESS
    // DF address compression compiled out (CT_EN_DF_ADDR_COMPRESS = 0):
    // the mode field is a read-only constant 0 (only full addresses); the
    // WARL wrapper additionally legalizes any write attempt to 0.
    te.trTeDataControl.DataAddrCompress ->sw = r;
`else
    te.trTeDataControl.DataAddrCompress->swwel = te.trTeControl.Enable;
`endif
`ifdef CT_PROFILE_NO_FILTERS
    te.trTeDataFilters.Filters          ->sw = r;
`else
    te.trTeDataFilters.Filters      ->swwel = te.trTeControl.Enable;
`endif
`endif

    // ----------------------------------------------------------------
    // ACT/perfcnt group: gated by the CT_EN_ACT build switch.
    // ----------------------------------------------------------------
`ifdef CT_PROFILE_NO_ACT
    // Indirect watchpoint load/readback path (C0b): without the ACT blocks
    // there is no table to load -- index/staging become read-only constants
    // and the capacity reads 0 (discovery-honest, trTsControl.Width pattern).
    trWpIndex.Idx            ->sw = r;
    trWpDataLow.Value        ->sw = r;
    trWpDataHigh.Cmd         ->sw = r;
    trWpDataHigh.Sink        ->sw = r;
    trWpDataHigh.DirectData  ->sw = r;
    trWpCap.Entries          ->reset = 16'd0;
    pc.trPerfCntControl.IFetchThreshold   ->sw = r;
    pc.trPerfCntControl.DataWrThreshold   ->sw = r;
    pc.trTePerfCntIFetchRange.Low.Value   ->sw = r;
    pc.trTePerfCntIFetchRange.High.Value  ->sw = r;
    pc.trTePerfCntDataRdThRange.Low.Value ->sw = r;
    pc.trTePerfCntDataRdThRange.High.Value->sw = r;
    pc.trTePerfCntDataRdRange.Low.Value   ->sw = r;
    pc.trTePerfCntDataRdRange.High.Value  ->sw = r;
    pc.trTePerfCntDataWrRange.Low.Value   ->sw = r;
    pc.trTePerfCntDataWrRange.High.Value  ->sw = r;
`else
    // Indirect watchpoint load/readback path (C0b): the table may only
    // change while tracing is disabled -- rule 4 of trWpDataHigh is
    // hardware-enforced here (the wrapper additionally suppresses the
    // commit pulse while Enable=1).
    trWpIndex.Idx            ->swwel = te.trTeControl.Enable;
    trWpDataLow.Value        ->swwel = te.trTeControl.Enable;
    trWpDataHigh.Cmd         ->swwel = te.trTeControl.Enable;
    trWpDataHigh.Sink        ->swwel = te.trTeControl.Enable;
    trWpDataHigh.DirectData  ->swwel = te.trTeControl.Enable;
    // Performance-counter address-range arrays (all use .Low.Value and .High.Value)
    pc.trTePerfCntIFetchRange.Low.Value   ->swwel = te.trTeControl.Enable;
    pc.trTePerfCntIFetchRange.High.Value  ->swwel = te.trTeControl.Enable;
    pc.trTePerfCntDataRdThRange.Low.Value ->swwel = te.trTeControl.Enable;
    pc.trTePerfCntDataRdThRange.High.Value->swwel = te.trTeControl.Enable;
    pc.trTePerfCntDataRdRange.Low.Value   ->swwel = te.trTeControl.Enable;
    pc.trTePerfCntDataRdRange.High.Value  ->swwel = te.trTeControl.Enable;
    pc.trTePerfCntDataWrRange.Low.Value   ->swwel = te.trTeControl.Enable;
    pc.trTePerfCntDataWrRange.High.Value  ->swwel = te.trTeControl.Enable;
`endif

    // ----------------------------------------------------------------
    // Compression-suite feature bits: one define per feature (matching
    // the per-feature CT_EN_* switches in ct_pkg). A compiled-out
    // feature's enable bit reads 0 and is not writable; a built-in one is
    // Enable-locked configuration like every other field of this register
    // (U10 F-1). It was not, until 2026-08-16: the register's own
    // description ("Only accessible on trTeControl. Enable=0") and
    // doc/integration.adoc ("All trTeInstFeatures ... writable only while
    // trTeControl.Enable=0") both promised the lock, only this list did
    // not implement it -- so a feature bit could be flipped mid-session,
    // silently changing the message grammar the decoder was started with
    // (and which TCODE 58 had already advertised on-wire). The lock is the
    // promised behaviour, not a new restriction: the documented programming
    // order is Active -> configuration -> Enable+InstTracing.
    // ----------------------------------------------------------------
`ifdef CT_PROFILE_NO_IMPLICIT_RETURN
    te.trTeInstFeatures.InstEnImplicitReturn   ->sw = r;
`else
    te.trTeInstFeatures.InstEnImplicitReturn   ->swwel = te.trTeControl.Enable;
`endif
`ifdef CT_PROFILE_NO_BP
    te.trTeInstFeatures.InstEnBranchPrediction ->sw = r;
`else
    te.trTeInstFeatures.InstEnBranchPrediction ->swwel = te.trTeControl.Enable;
`endif
`ifdef CT_PROFILE_NO_JTC
    te.trTeInstFeatures.InstEnJumpTargetCache  ->sw = r;
`else
    te.trTeInstFeatures.InstEnJumpTargetCache  ->swwel = te.trTeControl.Enable;
`endif
`ifdef CT_PROFILE_NO_REPEATED_HISTORY
    te.trTeInstFeatures.InstEnRepeatedHistory  ->sw = r;
`else
    te.trTeInstFeatures.InstEnRepeatedHistory  ->swwel = te.trTeControl.Enable;
`endif
`ifdef CT_PROFILE_NO_REPEAT_BRANCH
    te.trTeInstFeatures.InstEnRepeatBranch     ->sw = r;
`else
    te.trTeInstFeatures.InstEnRepeatBranch     ->swwel = te.trTeControl.Enable;
`endif
`ifdef CT_PROFILE_NO_WIDE_ICNT
    te.trTeInstFeatures.InstEnWideIcnt         ->sw = r;
`else
    te.trTeInstFeatures.InstEnWideIcnt         ->swwel = te.trTeControl.Enable;
`endif
`ifdef CT_PROFILE_NO_IBHS
    te.trTeInstFeatures.InstEnIbhs             ->sw = r;
`else
    te.trTeInstFeatures.InstEnIbhs             ->swwel = te.trTeControl.Enable;
`endif
`ifdef CT_PROFILE_NO_REPEAT_INSTR
    te.trTeInstFeatures.InstEnRepeatInstr      ->sw = r;
`else
    te.trTeInstFeatures.InstEnRepeatInstr      ->swwel = te.trTeControl.Enable;
`endif
`ifdef CT_PROFILE_NO_TRIG_SYNC
    te.trTeControl.InstTrigEnable              ->sw = r;
`endif
`ifdef CT_PROFILE_NO_SEQ_SYNC
    te.trTeControl.InstSeqSyncEnable           ->sw = r;
`endif
`ifdef CT_PROFILE_NO_OWNERSHIP
    te.trTeControl.Context                     ->sw = r;
`endif
`ifdef CT_PROFILE_NO_CONFIG_MSG
    te.trTeControl.SendConfig                  ->sw = r;
    te.trTeControl.SendConfig                  ->reset = 2'd0;
`endif
`ifdef CT_PROFILE_NO_DEVICE_ID
    // Device ID message compiled out (CT_EN_DEVICE_ID = 0): the mode field
    // is a read-only constant DID_NONE (its reset value already).
    te.trTeControl.SendDeviceId                ->sw = r;
`else
    te.trTeControl.SendDeviceId                ->swwel = te.trTeControl.Enable;
`endif
`ifdef CT_PROFILE_NO_WATCHPOINT_MSG
    // Watchpoint message compiled out (CT_EN_WATCHPOINT_MSG = 0): the slot
    // mask is a read-only constant 0 -- no hit can ever be reported.
    trWpMask.WEM                               ->sw = r;
`else
    trWpMask.WEM                               ->swwel = te.trTeControl.Enable;
`endif
`ifdef CT_PROFILE_NO_TRIG_REGS
    // Trigger configuration block compiled out (CT_EN_TRIG_REGS = 0): the one
    // implemented action field becomes a read-only constant 0 ("no action" --
    // exactly the TCI answer for a trigger input that cannot act). The
    // wrapper's WARL additionally legalizes any write to 0. The two
    // non-existent-trigger registers (0x050 / 0x058) are read-only 0 anyway.
    te.trTeTrigExtInControl.ExtInAction0       ->sw = r;
`else
    te.trTeTrigExtInControl.ExtInAction0       ->swwel = te.trTeControl.Enable;
`endif

    // ----------------------------------------------------------------
    // Timestamp unit: gated by the CT_EN_TIMESTAMP build switch. Compiled
    // out -> every trTsControl field is a read-only constant 0; Enable's
    // reset flips 1 -> 0 (no TS hardware => no TSTAMP fields on the wire)
    // and Width reads 0 = "no timestamp implemented" (discovery-honest).
    // trTsCounterLow/High read 0 through the wrapper tie-off.
    // ----------------------------------------------------------------
`ifdef CT_PROFILE_NO_TIMESTAMP
    te.trTsControl.Active   ->sw = r;
    te.trTsControl.Count    ->sw = r;
    te.trTsControl.Reset    ->sw = r;
    te.trTsControl.Type     ->sw = r;
    te.trTsControl.Prescale ->sw = r;
    te.trTsControl.Enable   ->sw = r;
    te.trTsControl.Enable   ->reset = 1'b0;
    te.trTsControl.Width    ->reset = 6'd0;
`endif

    // ATB bridge config
    atb.trAtbBridgeControl.ID       ->swwel = te.trTeControl.Enable;
    atb.trAtbBridgeImpl.AsyncFreq   ->swwel = te.trTeControl.Enable;

};
